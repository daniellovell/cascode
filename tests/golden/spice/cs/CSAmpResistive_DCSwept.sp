* CSAmpResistive_DCSwept - Generated from ACIR EL

.subckt CSAmpResistive_DCSwept IN OUT VDD GND

MM_in OUT IN GND GND nmos W=10u L=180n m=1
RR_load VDD OUT 10k

.ends CSAmpResistive_DCSwept
