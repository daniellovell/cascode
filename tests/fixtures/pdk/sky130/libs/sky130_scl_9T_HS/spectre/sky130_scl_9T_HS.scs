// Design: work/allCells_HS
simulator lang=spectre
global 0 VSS! VDD!
include "/vols/wfo_devel/projects/reference_SKY130/tech/sky130_release_0.0.4/libs/sky130_fd_pr_main/../../models/sky130.lib.spice" section=tt

// sky130_scl_9T_HS/OR4X2_HS/schematic
subckt OR4X2_HS A B C D VDD VSS Y
    mp4 (Y n0 VDD VDD) pfet_01v8 w=1.13u l=150n m=2
    mp0 (n1 A VDD VDD) pfet_01v8 w=1.13u l=150n m=2
    mp3 (n0 D n3 VDD) pfet_01v8 w=(780n) l=150n m=(1)*(1)
    mp1 (n2 B n1 VDD) pfet_01v8 w=(780n) l=150n m=(1)*(1)
    mp2 (n3 C n2 VDD) pfet_01v8 w=(780n) l=150n m=(1)*(1)
    mn4 (Y n0 VSS VSS) nfet_01v8_lvt w=(760n) l=150n m=(1)*(2)
    mn3 (n0 D VSS VSS) nfet_01v8_lvt w=(425n) l=150n m=(1)*(1)
    mn0 (n0 A VSS VSS) nfet_01v8_lvt w=(425n) l=150n m=(1)*(1)
    mn2 (n0 C VSS VSS) nfet_01v8_lvt w=(425n) l=150n m=(1)*(1)
    mn1 (n0 B VSS VSS) nfet_01v8_lvt w=(425n) l=150n m=(1)*(1)
ends OR4X2_HS

// sky130_scl_9T_HS/OAI221X2_HS/schematic
subckt OAI221X2_HS A0 A1 B0 B1 C0 VDD VSS Y
    mp3 (Y B1 net123 VDD) pfet_01v8 w=(1.46u) l=150n m=(1)*(2)
    mp0 (net115 A0 VDD VDD) pfet_01v8 w=1.13u l=150n m=2
    mp1 (Y A1 net115 VDD) pfet_01v8 w=(1.46u) l=150n m=(1)*(2)
    mp2 (net123 B0 VDD VDD) pfet_01v8 w=(1.46u) l=150n m=(1)*(2)
    mp4 (Y C0 VDD VDD) pfet_01v8 w=(1.46u) l=150n m=(1)*(2)
    mn4 (Y C0 net132 VSS) nfet_01v8_lvt w=(760n) l=150n m=(1)*(2)
    mn0 (net128 A0 VSS VSS) nfet_01v8_lvt w=(760n) l=150n m=(1)*(2)
    mn1 (net128 A1 VSS VSS) nfet_01v8_lvt w=(760n) l=150n m=(1)*(2)
    mn2 (net132 B0 net128 VSS) nfet_01v8_lvt w=(760n) l=150n m=(1)*(2)
    mn3 (net132 B1 net128 VSS) nfet_01v8_lvt w=(760n) l=150n m=(1)*(2)
ends OAI221X2_HS

// sky130_scl_9T_HS/INVX16_HS/schematic
subckt INVX16_HS A VDD VSS Y
    mp0 (Y A VDD VDD) pfet_01v8 w=1.13u l=150n m=2
    mn0 (Y A VSS VSS) nfet_01v8_lvt w=(760n) l=150n m=(1)*(16)
ends INVX16_HS

// sky130_scl_9T_HS/INVX2_HS/schematic
subckt INVX2_HS A VDD VSS Y
    mp0 (Y A VDD VDD) pfet_01v8 w=625n l=150n m=1
    mn0 (Y A VSS VSS) nfet_01v8_lvt w=(760n) l=150n m=(1)*(2)
ends INVX2_HS

// sky130_scl_9T_HS/MX2X1_HS/schematic
subckt MX2X1_HS A B S0 VDD VSS Y
    mp4 (n0 S0b n6 VDD) pfet_01v8 w=(780n) l=150n m=(1)*(1)
    mp3 (n6 B VDD VDD) pfet_01v8 w=(780n) l=150n m=(1)*(1)
    mp5 (Y n0 VDD VDD) pfet_01v8 w=625n l=150n m=1
    mp0 (S0b S0 VDD VDD) pfet_01v8 w=(780n) l=150n m=(1)*(1)
    mp2 (n0 S0 n4 VDD) pfet_01v8 w=625n l=150n m=1
    mp1 (n4 A VDD VDD) pfet_01v8 w=(780n) l=150n m=(1)*(1)
    mn3 (n5 B VSS VSS) nfet_01v8_lvt w=(425n) l=150n m=(1)*(1)
    mn4 (n0 S0 n5 VSS) nfet_01v8_lvt w=(425n) l=150n m=(1)*(1)
    mn0 (S0b S0 VSS VSS) nfet_01v8_lvt w=(425n) l=150n m=(1)*(1)
    mn1 (n3 A VSS VSS) nfet_01v8_lvt w=(425n) l=150n m=(1)*(1)
    mn5 (Y n0 VSS VSS) nfet_01v8_lvt w=(760n) l=150n m=(1)*(1)
    mn2 (n0 S0b n3 VSS) nfet_01v8_lvt w=(425n) l=150n m=(1)*(1)
ends MX2X1_HS

// sky130_scl_9T_HS/AOI21X2_HS/schematic
subckt AOI21X2_HS A0 A1 B0 VDD VSS Y
    mp2 (Y B0 net70 VDD) pfet_01v8 w=1.13u l=150n m=1
    mp1 (net70 A1 VDD VDD) pfet_01v8 w=(1.46u) l=150n m=(1)*(2)
    mp0 (net70 A0 VDD VDD) pfet_01v8 w=(1.46u) l=150n m=(1)*(2)
    mn2 (Y B0 VSS VSS) nfet_01v8_lvt w=(760n) l=150n m=(1)*(2)
    mn0 (net74 A0 VSS VSS) nfet_01v8_lvt w=(760n) l=150n m=(1)*(2)
    mn1 (Y A1 net74 VSS) nfet_01v8_lvt w=(760n) l=150n m=(1)*(2)
ends AOI21X2_HS

// sky130_scl_9T_HS/NOR4X2_HS/schematic
subckt NOR4X2_HS A B C D VDD VSS Y
    mp1 (n1 B n0 VDD) pfet_01v8 w=(1.46u) l=150n m=(1)*(2)
    mp3 (Y D n2 VDD) pfet_01v8 w=(1.46u) l=150n m=(1)*(2)
    mp2 (n2 C n1 VDD) pfet_01v8 w=(1.46u) l=150n m=(1)*(2)
    mp0 (n0 A VDD VDD) pfet_01v8 w=1.13u l=150n m=2
    mn2 (Y C VSS VSS) nfet_01v8_lvt w=(760n) l=150n m=(1)*(2)
    mn3 (Y D VSS VSS) nfet_01v8_lvt w=(760n) l=150n m=(1)*(2)
    mn0 (Y A VSS VSS) nfet_01v8_lvt w=(760n) l=150n m=(1)*(2)
    mn1 (Y B VSS VSS) nfet_01v8_lvt w=(760n) l=150n m=(1)*(2)
ends NOR4X2_HS

// sky130_scl_9T_HS/AOI221X2_HS/schematic
subckt AOI221X2_HS A0 A1 B0 B1 C0 VDD VSS Y
    mp3 (net104 B1 net103 VDD) pfet_01v8 w=(1.46u) l=150n m=(1)*(2)
    mp2 (net104 B0 net103 VDD) pfet_01v8 w=(1.46u) l=150n m=(1)*(2)
    mp0 (net103 A0 VDD VDD) pfet_01v8 w=(1.46u) l=150n m=(1)*(2)
    mp1 (net103 A1 VDD VDD) pfet_01v8 w=(1.46u) l=150n m=(1)*(2)
    mp4 (Y C0 net104 VDD) pfet_01v8 w=1.13u l=150n m=1
    mn2 (Y B0 net116 VSS) nfet_01v8_lvt w=(760n) l=150n m=(1)*(2)
    mn3 (net116 B1 VSS VSS) nfet_01v8_lvt w=(760n) l=150n m=(1)*(2)
    mn4 (Y C0 VSS VSS) nfet_01v8_lvt w=(760n) l=150n m=(1)*(2)
    mn1 (Y A1 net124 VSS) nfet_01v8_lvt w=(760n) l=150n m=(1)*(2)
    mn0 (net124 A0 VSS VSS) nfet_01v8_lvt w=(760n) l=150n m=(1)*(2)
ends AOI221X2_HS

// sky130_scl_9T_HS/NOR4X1_HS/schematic
subckt NOR4X1_HS A B C D VDD VSS Y
    mp1 (n1 B n0 VDD) pfet_01v8 w=(1.46u) l=150n m=(1)*(1)
    mp3 (Y D n2 VDD) pfet_01v8 w=(1.46u) l=150n m=(1)*(1)
    mp2 (n2 C n1 VDD) pfet_01v8 w=(1.46u) l=150n m=(1)*(1)
    mp0 (n0 A VDD VDD) pfet_01v8 w=1.13u l=150n m=1
    mn2 (Y C VSS VSS) nfet_01v8_lvt w=(760n) l=150n m=(1)*(1)
    mn3 (Y D VSS VSS) nfet_01v8_lvt w=(760n) l=150n m=(1)*(1)
    mn0 (Y A VSS VSS) nfet_01v8_lvt w=(760n) l=150n m=(1)*(1)
    mn1 (Y B VSS VSS) nfet_01v8_lvt w=(760n) l=150n m=(1)*(1)
ends NOR4X1_HS

// sky130_scl_9T_HS/AOI221X1_HS/schematic
subckt AOI221X1_HS A0 A1 B0 B1 C0 VDD VSS Y
    mp3 (net108 B1 net111 VDD) pfet_01v8 w=(1.46u) l=150n m=(1)*(1)
    mp2 (net108 B0 net111 VDD) pfet_01v8 w=(1.46u) l=150n m=(1)*(1)
    mp0 (net111 A0 VDD VDD) pfet_01v8 w=(1.46u) l=150n m=(1)*(1)
    mp1 (net111 A1 VDD VDD) pfet_01v8 w=(1.46u) l=150n m=(1)*(1)
    mp4 (Y C0 net108 VDD) pfet_01v8 w=1.13u l=150n m=2
    mn2 (net120 B0 VSS VSS) nfet_01v8_lvt w=(760n) l=150n m=(1)*(1)
    mn3 (Y B1 net120 VSS) nfet_01v8_lvt w=(760n) l=150n m=(1)*(1)
    mn4 (Y C0 VSS VSS) nfet_01v8_lvt w=(760n) l=150n m=(1)*(1)
    mn1 (Y A1 net128 VSS) nfet_01v8_lvt w=(760n) l=150n m=(1)*(1)
    mn0 (net128 A0 VSS VSS) nfet_01v8_lvt w=(760n) l=150n m=(1)*(1)
ends AOI221X1_HS

// sky130_scl_9T_HS/DFFX1_HS/schematic
subckt DFFX1_HS CK D Q QN VDD VSS
    mp26 (n20 CKbb n22 VDD) pfet_01v8 w=(780n) l=150n m=(1)*(1)
    mp25 (n22 D VDD VDD) pfet_01v8 w=(780n) l=150n m=(1)*(1)
    mp51 (n30 CKbb n36 VDD) pfet_01v8 w=(780n) l=150n m=(1)*(1)
    mp50 (n36 qbint VDD VDD) pfet_01v8 w=(780n) l=150n m=(1)*(1)
    mp57 (QN qint VDD VDD) pfet_01v8 w=(1.46u) l=150n m=(1)*(1)
    mp55 (Q qbint VDD VDD) pfet_01v8 w=625n l=150n m=1
    mp35 (n26 mout VDD VDD) pfet_01v8 w=(780n) l=150n m=(1)*(1)
    mp36 (n20 CKb n26 VDD) pfet_01v8 w=625n l=150n m=1
    mp20 (CKb CK VDD VDD) pfet_01v8 w=(780n) l=150n m=(1)*(1)
    mp45 (qbint n30 VDD VDD) pfet_01v8 w=(780n) l=150n m=(1)*(1)
    mp56 (qint qbint VDD VDD) pfet_01v8 w=(780n) l=150n m=(1)*(1)
    mp21 (CKbb CKb VDD VDD) pfet_01v8 w=(780n) l=150n m=(1)*(1)
    mp40 (n30 CKb mout VDD) pfet_01v8 w=(780n) l=150n m=(1)*(1)
    mp30 (mout n20 VDD VDD) pfet_01v8 w=(780n) l=150n m=(1)*(1)
    mn26 (n20 CKb n21 VSS) nfet_01v8_lvt w=(425n) l=150n m=(1)*(1)
    mn25 (n21 D VSS VSS) nfet_01v8_lvt w=(425n) l=150n m=(1)*(1)
    mn57 (QN qint VSS VSS) nfet_01v8_lvt w=(760n) l=150n m=(1)*(1)
    mn55 (Q qbint VSS VSS) nfet_01v8_lvt w=(760n) l=150n m=(1)*(1)
    mn50 (n35 qbint VSS VSS) nfet_01v8_lvt w=(425n) l=150n m=(1)*(1)
    mn51 (n30 CKb n35 VSS) nfet_01v8_lvt w=(425n) l=150n m=(1)*(1)
    mn35 (n25 mout VSS VSS) nfet_01v8_lvt w=(425n) l=150n m=(1)*(1)
    mn36 (n20 CKbb n25 VSS) nfet_01v8_lvt w=(425n) l=150n m=(1)*(1)
    mn20 (CKb CK VSS VSS) nfet_01v8_lvt w=(425n) l=150n m=(1)*(1)
    mn45 (qbint n30 VSS VSS) nfet_01v8_lvt w=(425n) l=150n m=(1)*(1)
    mn56 (qint qbint VSS VSS) nfet_01v8_lvt w=(425n) l=150n m=(1)*(1)
    mn21 (CKbb CKb VSS VSS) nfet_01v8_lvt w=(425n) l=150n m=(1)*(1)
    mn30 (mout n20 VSS VSS) nfet_01v8_lvt w=(425n) l=150n m=(1)*(1)
    mn40 (n30 CKbb mout VSS) nfet_01v8_lvt w=(425n) l=150n m=(1)*(1)
ends DFFX1_HS

// sky130_scl_9T_HS/DFFRX4_HS/schematic
subckt DFFRX4_HS CK D Q QN RN VDD VSS
    mp26 (n20 CKbb n22 VDD) pfet_01v8 w=(780n) l=150n m=(1)*(1)
    mp25 (n22 D VDD VDD) pfet_01v8 w=(780n) l=150n m=(1)*(1)
    mp51 (n30 CKbb n41 VDD) pfet_01v8 w=(780n) l=150n m=(1)*(1)
    mp50 (n41 qbint VDD VDD) pfet_01v8 w=(780n) l=150n m=(1)*(1)
    mp57 (QN qint VDD VDD) pfet_01v8 w=(1.46u) l=150n m=(1)*(4)
    mp55 (Q qbint VDD VDD) pfet_01v8 w=905n l=150n m=2
    mp20 (CKb CK VDD VDD) pfet_01v8 w=(780n) l=150n m=(1)*(1)
    mp21 (CKbb CKb VDD VDD) pfet_01v8 w=(780n) l=150n m=(1)*(1)
    mp36 (n26 mout VDD VDD) pfet_01v8 w=(780n) l=150n m=(1)*(1)
    mp30 (mout n20 VDD VDD) pfet_01v8 w=(780n) l=150n m=(1)*(1)
    mp35 (n26 RN VDD VDD) pfet_01v8 w=(780n) l=150n m=(1)*(1)
    mp37 (n20 CKb n26 VDD) pfet_01v8 w=905n l=150n m=2
    mp46 (qbint n30 VDD VDD) pfet_01v8 w=(1.25u) l=150n m=(1)*(2)
    mp40 (n30 CKb mout VDD) pfet_01v8 w=(780n) l=150n m=(1)*(1)
    mp45 (qbint RN VDD VDD) pfet_01v8 w=905n l=150n m=2
    mp56 (qint qbint VDD VDD) pfet_01v8 w=905n l=150n m=2
    mn36 (n25 mout n27 VSS) nfet_01v8_lvt w=(425n) l=150n m=(1)*(1)
    mn35 (n27 RN VSS VSS) nfet_01v8_lvt w=(425n) l=150n m=(1)*(1)
    mn37 (n20 CKbb n25 VSS) nfet_01v8_lvt w=(425n) l=150n m=(1)*(1)
    mn26 (n20 CKb n21 VSS) nfet_01v8_lvt w=(425n) l=150n m=(1)*(1)
    mn25 (n21 D VSS VSS) nfet_01v8_lvt w=(425n) l=150n m=(1)*(1)
    mn57 (QN qint VSS VSS) nfet_01v8_lvt w=(760n) l=150n m=(1)*(4)
    mn55 (Q qbint VSS VSS) nfet_01v8_lvt w=(760n) l=150n m=(1)*(4)
    mn45 (n35 RN VSS VSS) nfet_01v8_lvt w=(600n) l=150n m=(1)*(2)
    mn46 (qbint n30 n35 VSS) nfet_01v8_lvt w=(600n) l=150n m=(1)*(2)
    mn51 (n30 CKb n40 VSS) nfet_01v8_lvt w=(425n) l=150n m=(1)*(1)
    mn50 (n40 qbint VSS VSS) nfet_01v8_lvt w=(425n) l=150n m=(1)*(1)
    mn21 (CKbb CKb VSS VSS) nfet_01v8_lvt w=(425n) l=150n m=(1)*(1)
    mn40 (n30 CKbb mout VSS) nfet_01v8_lvt w=(425n) l=150n m=(1)*(1)
    mn30 (mout n20 VSS VSS) nfet_01v8_lvt w=(425n) l=150n m=(1)*(1)
    mn56 (qint qbint VSS VSS) nfet_01v8_lvt w=(760n) l=150n m=(1)*(1)
    mn20 (CKb CK VSS VSS) nfet_01v8_lvt w=(425n) l=150n m=(1)*(1)
ends DFFRX4_HS

// sky130_scl_9T_HS/AOI21X1_HS/schematic
subckt AOI21X1_HS A0 A1 B0 VDD VSS Y
    mp2 (Y B0 net62 VDD) pfet_01v8 w=625n l=150n m=1
    mp1 (net62 A1 VDD VDD) pfet_01v8 w=(1.46u) l=150n m=(1)*(1)
    mp0 (net62 A0 VDD VDD) pfet_01v8 w=(1.46u) l=150n m=(1)*(1)
    mn2 (Y B0 VSS VSS) nfet_01v8_lvt w=(760n) l=150n m=(1)*(1)
    mn0 (net78 A0 VSS VSS) nfet_01v8_lvt w=(760n) l=150n m=(1)*(1)
    mn1 (Y A1 net78 VSS) nfet_01v8_lvt w=(760n) l=150n m=(1)*(1)
ends AOI21X1_HS

// sky130_scl_9T_HS/INVX1_HS/schematic
subckt INVX1_HS A VDD VSS Y
    mn0 (Y A VSS VSS) nfet_01v8_lvt w=760n l=150n m=1
    mp0 (Y A VDD VDD) pfet_01v8 w=760n l=150n m=1
ends INVX1_HS

// sky130_scl_9T_HS/OR4X1_HS/schematic
subckt OR4X1_HS A B C D VDD VSS Y
    mp4 (Y n0 VDD VDD) pfet_01v8 w=(1.46u) l=150n m=(1)*(1)
    mp0 (n1 A VDD VDD) pfet_01v8 w=(780n) l=150n m=(1)*(1)
    mp3 (n0 D n3 VDD) pfet_01v8 w=(780n) l=150n m=(1)*(1)
    mp1 (n2 B n1 VDD) pfet_01v8 w=(780n) l=150n m=(1)*(1)
    mp2 (n3 C n2 VDD) pfet_01v8 w=(780n) l=150n m=(1)*(1)
    mn4 (Y n0 VSS VSS) nfet_01v8_lvt w=(760n) l=150n m=(1)*(1)
    mn3 (n0 D VSS VSS) nfet_01v8_lvt w=(425n) l=150n m=(1)*(1)
    mn0 (n0 A VSS VSS) nfet_01v8_lvt w=(425n) l=150n m=(1)*(1)
    mn2 (n0 C VSS VSS) nfet_01v8_lvt w=(425n) l=150n m=(1)*(1)
    mn1 (n0 B VSS VSS) nfet_01v8_lvt w=(425n) l=150n m=(1)*(1)
ends OR4X1_HS

// sky130_scl_9T_HS/OAI221X1_HS/schematic
subckt OAI221X1_HS A0 A1 B0 B1 C0 VDD VSS Y
    mp3 (Y B1 net123 VDD) pfet_01v8 w=(1.46u) l=150n m=(1)*(1)
    mp0 (net115 A0 VDD VDD) pfet_01v8 w=1.13u l=150n m=1
    mp1 (Y A1 net115 VDD) pfet_01v8 w=(1.46u) l=150n m=(1)*(1)
    mp2 (net123 B0 VDD VDD) pfet_01v8 w=(1.46u) l=150n m=(1)*(1)
    mp4 (Y C0 VDD VDD) pfet_01v8 w=(1.46u) l=150n m=(1)*(1)
    mn4 (Y C0 net132 VSS) nfet_01v8_lvt w=(760n) l=150n m=(1)*(1)
    mn0 (net128 A0 VSS VSS) nfet_01v8_lvt w=(760n) l=150n m=(1)*(1)
    mn1 (net128 A1 VSS VSS) nfet_01v8_lvt w=(760n) l=150n m=(1)*(1)
    mn2 (net132 B0 net128 VSS) nfet_01v8_lvt w=(760n) l=150n m=(1)*(1)
    mn3 (net132 B1 net128 VSS) nfet_01v8_lvt w=(760n) l=150n m=(1)*(1)
ends OAI221X1_HS

// sky130_scl_9T_HS/DLY4X4_HS/schematic
subckt DLY4X4_HS A VDD VSS Y
    mp8 (net369 VSS net300 VDD) pfet_01v8 w=(780n) l=150n m=(1)*(1)
    mp7 (net300 net377 VDD VDD) pfet_01v8 w=(780n) l=150n m=(1)*(1)
    mp9 (net292 net369 VDD VDD) pfet_01v8 w=(780n) l=150n m=(1)*(1)
    mp10 (net361 VSS net292 VDD) pfet_01v8 w=(780n) l=150n m=(1)*(1)
    mp6 (net377 VSS net308 VDD) pfet_01v8 w=(780n) l=150n m=(1)*(1)
    mp5 (net308 net385 VDD VDD) pfet_01v8 w=(780n) l=150n m=(1)*(1)
    mp4 (net385 VSS net316 VDD) pfet_01v8 w=(780n) l=150n m=(1)*(1)
    mp3 (net316 net393 VDD VDD) pfet_01v8 w=(780n) l=150n m=(1)*(1)
    mp2 (net393 VSS net324 VDD) pfet_01v8 w=(780n) l=150n m=(1)*(1)
    mp1 (net324 net397 VDD VDD) pfet_01v8 w=(780n) l=150n m=(1)*(1)
    mp11 (net284 net361 VDD VDD) pfet_01v8 w=(780n) l=150n m=(1)*(1)
    mp12 (net353 VSS net284 VDD) pfet_01v8 w=(780n) l=150n m=(1)*(1)
    mp13 (net276 net353 VDD VDD) pfet_01v8 w=(780n) l=150n m=(1)*(1)
    mp14 (net345 VSS net276 VDD) pfet_01v8 w=(780n) l=150n m=(1)*(1)
    mp15 (net333 net345 VDD VDD) pfet_01v8 w=(1.46u) l=150n m=(1)*(1)
    mp0 (net397 A VDD VDD) pfet_01v8 w=(780n) l=150n m=(1)*(1)
    mp16 (Y net333 VDD VDD) pfet_01v8 w=(1.46u) l=150n m=(1)*(4)
    mn14 (net345 VDD net341 VSS) nfet_01v8_lvt w=(425n) l=150n m=(1)*(1)
    mn13 (net341 net353 VSS VSS) nfet_01v8_lvt w=(425n) l=150n m=(1)*(1)
    mn12 (net353 VDD net349 VSS) nfet_01v8_lvt w=(425n) l=150n m=(1)*(1)
    mn11 (net349 net361 VSS VSS) nfet_01v8_lvt w=(425n) l=150n m=(1)*(1)
    mn10 (net361 VDD net357 VSS) nfet_01v8_lvt w=(425n) l=150n m=(1)*(1)
    mn9 (net357 net369 VSS VSS) nfet_01v8_lvt w=(425n) l=150n m=(1)*(1)
    mn15 (net333 net345 VSS VSS) nfet_01v8_lvt w=(760n) l=150n m=(1)*(1)
    mn6 (net377 VDD net373 VSS) nfet_01v8_lvt w=(425n) l=150n m=(1)*(1)
    mn0 (net397 A VSS VSS) nfet_01v8_lvt w=(425n) l=150n m=(1)*(1)
    mn4 (net385 VDD net381 VSS) nfet_01v8_lvt w=(425n) l=150n m=(1)*(1)
    mn1 (net389 net397 VSS VSS) nfet_01v8_lvt w=(425n) l=150n m=(1)*(1)
    mn7 (net365 net377 VSS VSS) nfet_01v8_lvt w=(425n) l=150n m=(1)*(1)
    mn16 (Y net333 VSS VSS) nfet_01v8_lvt w=(760n) l=150n m=(1)*(4)
    mn3 (net381 net393 VSS VSS) nfet_01v8_lvt w=(425n) l=150n m=(1)*(1)
    mn2 (net393 VDD net389 VSS) nfet_01v8_lvt w=(425n) l=150n m=(1)*(1)
    mn8 (net369 VDD net365 VSS) nfet_01v8_lvt w=(425n) l=150n m=(1)*(1)
    mn5 (net373 net385 VSS VSS) nfet_01v8_lvt w=(425n) l=150n m=(1)*(1)
ends DLY4X4_HS

// sky130_scl_9T_HS/AND3X1_HS/schematic
subckt AND3X1_HS A B C VDD VSS Y
    mp1 (net086 B VDD VDD) pfet_01v8 w=(780n) l=150n m=(1)*(1)
    mp2 (net086 C VDD VDD) pfet_01v8 w=(780n) l=150n m=(1)*(1)
    mp0 (net086 A VDD VDD) pfet_01v8 w=625n l=150n m=1
    mp3 (Y net086 VDD VDD) pfet_01v8 w=625n l=150n m=1
    mn3 (Y net086 VSS VSS) nfet_01v8_lvt w=(760n) l=150n m=(1)*(1)
    mn1 (net0106 B net0102 VSS) nfet_01v8_lvt w=(425n) l=150n m=(1)*(1)
    mn0 (net0102 A VSS VSS) nfet_01v8_lvt w=(425n) l=150n m=(1)*(1)
    mn2 (net086 C net0106 VSS) nfet_01v8_lvt w=(425n) l=150n m=(1)*(1)
ends AND3X1_HS

// sky130_scl_9T_HS/CLKXOR2X1_HS/schematic
subckt CLKXOR2X1_HS A B VDD VSS Y
    mp3 (n0 n2 net130 VDD) pfet_01v8 w=(780n) l=150n m=(1)*(1)
    mp1 (n2 B VDD VDD) pfet_01v8 w=(780n) l=150n m=(1)*(1)
    mp4 (n0 B n1 VDD) pfet_01v8 w=(780n) l=150n m=(1)*(1)
    mp0 (n1 A VDD VDD) pfet_01v8 w=(780n) l=150n m=(1)*(1)
    mp5 (Y n0 VDD VDD) pfet_01v8 w=(1.46u) l=150n m=(1)*(1)
    mp2 (net130 n1 VDD VDD) pfet_01v8 w=(780n) l=150n m=(1)*(1)
    mn1 (n2 B VSS VSS) nfet_01v8_lvt w=(425n) l=150n m=(1)*(1)
    mn0 (n1 A VSS VSS) nfet_01v8_lvt w=(425n) l=150n m=(1)*(1)
    mn5 (Y n0 VSS VSS) nfet_01v8_lvt w=(760n) l=150n m=(1)*(1)
    mn3 (n0 B net139 VSS) nfet_01v8_lvt w=(425n) l=150n m=(1)*(1)
    mn4 (n0 n2 n1 VSS) nfet_01v8_lvt w=(425n) l=150n m=(1)*(1)
    mn2 (net139 n1 VSS VSS) nfet_01v8_lvt w=(425n) l=150n m=(1)*(1)
ends CLKXOR2X1_HS

// sky130_scl_9T_HS/MX2X4_HS/schematic
subckt MX2X4_HS A B S0 VDD VSS Y
    mp4 (n0 S0b n6 VDD) pfet_01v8 w=(1.25u) l=150n m=(1)*(1)
    mp3 (n6 B VDD VDD) pfet_01v8 w=(1.25u) l=150n m=(1)*(1)
    mp5 (Y n0 VDD VDD) pfet_01v8 w=625n l=150n m=1
    mp0 (S0b S0 VDD VDD) pfet_01v8 w=625n l=150n m=1
    mp2 (n0 S0 n4 VDD) pfet_01v8 w=625n l=150n m=1
    mp1 (n4 A VDD VDD) pfet_01v8 w=(1.25u) l=150n m=(1)*(1)
    mn3 (n5 B VSS VSS) nfet_01v8_lvt w=(600n) l=150n m=(1)*(1)
    mn4 (n0 S0 n5 VSS) nfet_01v8_lvt w=(600n) l=150n m=(1)*(1)
    mn0 (S0b S0 VSS VSS) nfet_01v8_lvt w=(425n) l=150n m=(1)*(1)
    mn1 (n3 A VSS VSS) nfet_01v8_lvt w=(600n) l=150n m=(1)*(1)
    mn5 (Y n0 VSS VSS) nfet_01v8_lvt w=(760n) l=150n m=(1)*(4)
    mn2 (n0 S0b n3 VSS) nfet_01v8_lvt w=(600n) l=150n m=(1)*(1)
ends MX2X4_HS

// sky130_scl_9T_HS/BUFX8_HS/schematic
subckt BUFX8_HS A VDD VSS Y
    mp1 (Y n0 VDD VDD) pfet_01v8 w=1.13u l=150n m=1
    mp0 (n0 A VDD VDD) pfet_01v8 w=1.13u l=150n m=1
    mn1 (VSS n0 Y VSS) nfet_01v8_lvt w=(760n) l=150n m=(1)*(8)
    mn0 (VSS A n0 VSS) nfet_01v8_lvt w=(760n) l=150n m=(1)*(2)
ends BUFX8_HS

// sky130_scl_9T_HS/INVX4_HS/schematic
subckt INVX4_HS A VDD VSS Y
    mp0 (Y A VDD VDD) pfet_01v8 w=1.13u l=150n m=4
    mn0 (Y A VSS VSS) nfet_01v8_lvt w=(760n) l=150n m=(1)*(4)
ends INVX4_HS

// sky130_scl_9T_HS/DFFRX1_HS/schematic
subckt DFFRX1_HS CK D Q QN RN VDD VSS
    mp26 (n20 CKbb n22 VDD) pfet_01v8 w=(780n) l=150n m=(1)*(1)
    mp25 (n22 D VDD VDD) pfet_01v8 w=(780n) l=150n m=(1)*(1)
    mp51 (n30 CKbb n41 VDD) pfet_01v8 w=(780n) l=150n m=(1)*(1)
    mp50 (n41 qbint VDD VDD) pfet_01v8 w=(780n) l=150n m=(1)*(1)
    mp57 (QN qint VDD VDD) pfet_01v8 w=(1.46u) l=150n m=(1)*(1)
    mp55 (Q qbint VDD VDD) pfet_01v8 w=1.13u l=150n m=4
    mp20 (CKb CK VDD VDD) pfet_01v8 w=(780n) l=150n m=(1)*(1)
    mp21 (CKbb CKb VDD VDD) pfet_01v8 w=(780n) l=150n m=(1)*(1)
    mp36 (n26 mout VDD VDD) pfet_01v8 w=(780n) l=150n m=(1)*(1)
    mp30 (mout n20 VDD VDD) pfet_01v8 w=(780n) l=150n m=(1)*(1)
    mp35 (n26 RN VDD VDD) pfet_01v8 w=(780n) l=150n m=(1)*(1)
    mp37 (n20 CKb n26 VDD) pfet_01v8 w=1.13u l=150n m=4
    mp46 (qbint n30 VDD VDD) pfet_01v8 w=(780n) l=150n m=(1)*(1)
    mp40 (n30 CKb mout VDD) pfet_01v8 w=(780n) l=150n m=(1)*(1)
    mp45 (qbint RN VDD VDD) pfet_01v8 w=(780n) l=150n m=(1)*(1)
    mp56 (qint qbint VDD VDD) pfet_01v8 w=(780n) l=150n m=(1)*(1)
    mn36 (n25 mout n27 VSS) nfet_01v8_lvt w=(425n) l=150n m=(1)*(1)
    mn35 (n27 RN VSS VSS) nfet_01v8_lvt w=(425n) l=150n m=(1)*(1)
    mn37 (n20 CKbb n25 VSS) nfet_01v8_lvt w=(425n) l=150n m=(1)*(1)
    mn26 (n20 CKb n21 VSS) nfet_01v8_lvt w=(425n) l=150n m=(1)*(1)
    mn25 (n21 D VSS VSS) nfet_01v8_lvt w=(425n) l=150n m=(1)*(1)
    mn57 (QN qint VSS VSS) nfet_01v8_lvt w=(760n) l=150n m=(1)*(1)
    mn55 (Q qbint VSS VSS) nfet_01v8_lvt w=(760n) l=150n m=(1)*(1)
    mn45 (n35 RN VSS VSS) nfet_01v8_lvt w=(425n) l=150n m=(1)*(1)
    mn46 (qbint n30 n35 VSS) nfet_01v8_lvt w=(425n) l=150n m=(1)*(1)
    mn51 (n30 CKb n40 VSS) nfet_01v8_lvt w=(425n) l=150n m=(1)*(1)
    mn50 (n40 qbint VSS VSS) nfet_01v8_lvt w=(425n) l=150n m=(1)*(1)
    mn21 (CKbb CKb VSS VSS) nfet_01v8_lvt w=(425n) l=150n m=(1)*(1)
    mn40 (n30 CKbb mout VSS) nfet_01v8_lvt w=(425n) l=150n m=(1)*(1)
    mn30 (mout n20 VSS VSS) nfet_01v8_lvt w=(425n) l=150n m=(1)*(1)
    mn56 (qint qbint VSS VSS) nfet_01v8_lvt w=(425n) l=150n m=(1)*(1)
    mn20 (CKb CK VSS VSS) nfet_01v8_lvt w=(425n) l=150n m=(1)*(1)
ends DFFRX1_HS

// sky130_scl_9T_HS/TLATSRX1_HS/schematic
subckt TLATSRX1_HS D G Q QN RN SN VDD VSS
    PM0 (Gb RN VDD VDD) pfet_01v8 w=(780n) l=150n m=(1)*(1)
    PM1 (Qint SN VDD VDD) pfet_01v8 w=(780n) l=150n m=(1)*(1)
    mp26 (n0 Gb n22 VDD) pfet_01v8 w=(780n) l=150n m=(1)*(1)
    mp25 (n22 D VDD VDD) pfet_01v8 w=(780n) l=150n m=(1)*(1)
    mp57 (QN Qint VDD VDD) pfet_01v8 w=(1.46u) l=150n m=(1)*(1)
    mp55 (Qbint Qint VDD VDD) pfet_01v8 w=(1.46u) l=150n m=(1)*(1)
    mp35 (n26 Qint VDD VDD) pfet_01v8 w=(780n) l=150n m=(1)*(1)
    mp36 (n0 Gbb n26 VDD) pfet_01v8 w=625n l=150n m=1
    mp20 (Gb G VDD VDD) pfet_01v8 w=(780n) l=150n m=(1)*(1)
    mp56 (Q Qbint VDD VDD) pfet_01v8 w=625n l=150n m=1
    mp21 (Gbb Gb VDD VDD) pfet_01v8 w=(780n) l=150n m=(1)*(1)
    PM2 (n26 RN VDD VDD) pfet_01v8 w=(780n) l=150n m=(1)*(1)
    mp30 (Qint n0 VDD VDD) pfet_01v8 w=(780n) l=150n m=(1)*(1)
    mn26 (n0 Gbb n21 VSS) nfet_01v8_lvt w=(425n) l=150n m=(1)*(1)
    mn25 (n21 D VSS VSS) nfet_01v8_lvt w=(425n) l=150n m=(1)*(1)
    mn57 (QN Qint VSS VSS) nfet_01v8_lvt w=(760n) l=150n m=(1)*(1)
    mn55 (Qbint Qint VSS VSS) nfet_01v8_lvt w=(760n) l=150n m=(1)*(1)
    mn35 (n25 Qint net3 VSS) nfet_01v8_lvt w=(425n) l=150n m=(1)*(1)
    mn36 (n0 Gb n25 VSS) nfet_01v8_lvt w=(425n) l=150n m=(1)*(1)
    mn20 (Gb G net1 VSS) nfet_01v8_lvt w=(425n) l=150n m=(1)*(1)
    NM0 (net1 RN VSS VSS) nfet_01v8_lvt w=(425n) l=150n m=(1)*(1)
    mn56 (Q Qbint VSS VSS) nfet_01v8_lvt w=(760n) l=150n m=(1)*(1)
    mn21 (Gbb Gb VSS VSS) nfet_01v8_lvt w=(425n) l=150n m=(1)*(1)
    mn30 (Qint n0 net2 VSS) nfet_01v8_lvt w=(425n) l=150n m=(1)*(1)
    NM1 (net2 SN VSS VSS) nfet_01v8_lvt w=(425n) l=150n m=(1)*(1)
    NM2 (net3 RN VSS VSS) nfet_01v8_lvt w=(425n) l=150n m=(1)*(1)
ends TLATSRX1_HS

// sky130_scl_9T_HS/DFFX4_HS/schematic
subckt DFFX4_HS CK D Q QN VDD VSS
    mp26 (n20 CKbb n22 VDD) pfet_01v8 w=(780n) l=150n m=(1)*(1)
    mp25 (n22 D VDD VDD) pfet_01v8 w=(780n) l=150n m=(1)*(1)
    mp51 (n30 CKbb n36 VDD) pfet_01v8 w=(780n) l=150n m=(1)*(1)
    mp50 (n36 qbint VDD VDD) pfet_01v8 w=(780n) l=150n m=(1)*(1)
    mp57 (QN qint VDD VDD) pfet_01v8 w=(1.46u) l=150n m=(1)*(4)
    mp55 (Q qbint VDD VDD) pfet_01v8 w=(1.46u) l=150n m=(1)*(4)
    mp35 (n26 mout VDD VDD) pfet_01v8 w=(780n) l=150n m=(1)*(1)
    mp36 (n20 CKb n26 VDD) pfet_01v8 w=(780n) l=150n m=(1)*(1)
    mp20 (CKb CK VDD VDD) pfet_01v8 w=(780n) l=150n m=(1)*(1)
    mp45 (qbint n30 VDD VDD) pfet_01v8 w=(1.12u) l=150n m=(1)*(2)
    mp56 (qint qbint VDD VDD) pfet_01v8 w=(1.46u) l=150n m=(1)*(1)
    mp21 (CKbb CKb VDD VDD) pfet_01v8 w=(780n) l=150n m=(1)*(1)
    mp40 (n30 CKb mout VDD) pfet_01v8 w=(780n) l=150n m=(1)*(1)
    mp30 (mout n20 VDD VDD) pfet_01v8 w=(780n) l=150n m=(1)*(1)
    mn26 (n20 CKb n21 VSS) nfet_01v8_lvt w=(425n) l=150n m=(1)*(1)
    mn25 (n21 D VSS VSS) nfet_01v8_lvt w=(425n) l=150n m=(1)*(1)
    mn57 (QN qint VSS VSS) nfet_01v8_lvt w=(760n) l=150n m=(1)*(4)
    mn55 (Q qbint VSS VSS) nfet_01v8_lvt w=(760n) l=150n m=(1)*(4)
    mn50 (n35 qbint VSS VSS) nfet_01v8_lvt w=(425n) l=150n m=(1)*(1)
    mn51 (n30 CKb n35 VSS) nfet_01v8_lvt w=(425n) l=150n m=(1)*(1)
    mn35 (n25 mout VSS VSS) nfet_01v8_lvt w=(425n) l=150n m=(1)*(1)
    mn36 (n20 CKbb n25 VSS) nfet_01v8_lvt w=(425n) l=150n m=(1)*(1)
    mn20 (CKb CK VSS VSS) nfet_01v8_lvt w=(425n) l=150n m=(1)*(1)
    mn45 (qbint n30 VSS VSS) nfet_01v8_lvt w=(600n) l=150n m=(1)*(2)
    mn56 (qint qbint VSS VSS) nfet_01v8_lvt w=(760n) l=150n m=(1)*(1)
    mn21 (CKbb CKb VSS VSS) nfet_01v8_lvt w=(425n) l=150n m=(1)*(1)
    mn30 (mout n20 VSS VSS) nfet_01v8_lvt w=(425n) l=150n m=(1)*(1)
    mn40 (n30 CKbb mout VSS) nfet_01v8_lvt w=(425n) l=150n m=(1)*(1)
ends DFFX4_HS

// sky130_scl_9T_HS/AND3X2_HS/schematic
subckt AND3X2_HS A B C VDD VSS Y
    mp1 (net95 B VDD VDD) pfet_01v8 w=(780n) l=150n m=(1)*(1)
    mp2 (net95 C VDD VDD) pfet_01v8 w=(780n) l=150n m=(1)*(1)
    mp0 (net95 A VDD VDD) pfet_01v8 w=625n l=150n m=1
    mp3 (Y net95 VDD VDD) pfet_01v8 w=625n l=150n m=1
    mn3 (Y net95 VSS VSS) nfet_01v8_lvt w=(760n) l=150n m=(1)*(2)
    mn1 (net111 B net103 VSS) nfet_01v8_lvt w=(425n) l=150n m=(1)*(1)
    mn0 (net103 A VSS VSS) nfet_01v8_lvt w=(425n) l=150n m=(1)*(1)
    mn2 (net95 C net111 VSS) nfet_01v8_lvt w=(425n) l=150n m=(1)*(1)
ends AND3X2_HS

// sky130_scl_9T_HS/NOR4X4_HS/schematic
subckt NOR4X4_HS A B C D VDD VSS Y
    mp1 (n1 B n0 VDD) pfet_01v8 w=(1.46u) l=150n m=(1)*(4)
    mp3 (Y D n2 VDD) pfet_01v8 w=(1.46u) l=150n m=(1)*(4)
    mp2 (n2 C n1 VDD) pfet_01v8 w=(1.46u) l=150n m=(1)*(4)
    mp0 (n0 A VDD VDD) pfet_01v8 w=1.13u l=150n m=4
    mn2 (Y C VSS VSS) nfet_01v8_lvt w=(760n) l=150n m=(1)*(4)
    mn3 (Y D VSS VSS) nfet_01v8_lvt w=(760n) l=150n m=(1)*(4)
    mn0 (Y A VSS VSS) nfet_01v8_lvt w=(760n) l=150n m=(1)*(4)
    mn1 (Y B VSS VSS) nfet_01v8_lvt w=(760n) l=150n m=(1)*(4)
ends NOR4X4_HS

// sky130_scl_9T_HS/DFFSRX1_HS/schematic
subckt DFFSRX1_HS CK D Q QN RN SN VDD VSS
    mp26 (n20 CKbb n22 VDD) pfet_01v8 w=(780n) l=150n m=(1)*(1)
    mp25 (n22 D VDD VDD) pfet_01v8 w=(780n) l=150n m=(1)*(1)
    mp52 (n41 qbint n43 VDD) pfet_01v8 w=(780n) l=150n m=(1)*(1)
    mp51 (n43 RNb VDD VDD) pfet_01v8 w=(780n) l=150n m=(1)*(1)
    mp57 (QN qint VDD VDD) pfet_01v8 w=(1.46u) l=150n m=(1)*(1)
    mp55 (Q qbint VDD VDD) pfet_01v8 w=905n l=150n m=2
    mp36 (n20 CKb n31 VDD) pfet_01v8 w=(780n) l=150n m=(1)*(1)
    mp35 (n31 mout VDD VDD) pfet_01v8 w=(780n) l=150n m=(1)*(1)
    mp32 (mout n20 net402 VDD) pfet_01v8 w=(780n) l=150n m=(1)*(1)
    mp31 (net402 RNb VDD VDD) pfet_01v8 w=(780n) l=150n m=(1)*(1)
    mp22 (RNb RN VDD VDD) pfet_01v8 w=(780n) l=150n m=(1)*(1)
    mp20 (CKb CK VDD VDD) pfet_01v8 w=(780n) l=150n m=(1)*(1)
    mp53 (n35 CKbb n41 VDD) pfet_01v8 w=905n l=150n m=2
    mp50 (n41 SN VDD VDD) pfet_01v8 w=(780n) l=150n m=(1)*(1)
    mp45 (qbint n35 VDD VDD) pfet_01v8 w=(780n) l=150n m=(1)*(1)
    mp56 (qint qbint VDD VDD) pfet_01v8 w=905n l=150n m=2
    mp21 (CKbb CKb VDD VDD) pfet_01v8 w=(780n) l=150n m=(1)*(1)
    mp30 (mout SN VDD VDD) pfet_01v8 w=(780n) l=150n m=(1)*(1)
    mp40 (n35 CKb mout VDD) pfet_01v8 w=(780n) l=150n m=(1)*(1)
    mn26 (n20 CKb n21 VSS) nfet_01v8_lvt w=(425n) l=150n m=(1)*(1)
    mn25 (n21 D VSS VSS) nfet_01v8_lvt w=(425n) l=150n m=(1)*(1)
    mn57 (QN qint VSS VSS) nfet_01v8_lvt w=(760n) l=150n m=(1)*(1)
    mn55 (Q qbint VSS VSS) nfet_01v8_lvt w=(760n) l=150n m=(1)*(1)
    mn35 (n30 mout VSS VSS) nfet_01v8_lvt w=(425n) l=150n m=(1)*(1)
    mn36 (n20 CKbb n30 VSS) nfet_01v8_lvt w=(425n) l=150n m=(1)*(1)
    mn22 (RNb RN VSS VSS) nfet_01v8_lvt w=(425n) l=150n m=(1)*(1)
    mn20 (CKb CK VSS VSS) nfet_01v8_lvt w=(425n) l=150n m=(1)*(1)
    mn45 (qbint n35 VSS VSS) nfet_01v8_lvt w=(425n) l=150n m=(1)*(1)
    mn56 (qint qbint VSS VSS) nfet_01v8_lvt w=(425n) l=150n m=(1)*(1)
    mn52 (n40 qbint n42 VSS) nfet_01v8_lvt w=(425n) l=150n m=(1)*(1)
    mn51 (n40 RNb n42 VSS) nfet_01v8_lvt w=(425n) l=150n m=(1)*(1)
    mn50 (n42 SN VSS VSS) nfet_01v8_lvt w=(425n) l=150n m=(1)*(1)
    mn53 (n35 CKb n40 VSS) nfet_01v8_lvt w=(425n) l=150n m=(1)*(1)
    mn21 (CKbb CKb VSS VSS) nfet_01v8_lvt w=(425n) l=150n m=(1)*(1)
    mn32 (mout n20 net426 VSS) nfet_01v8_lvt w=(425n) l=150n m=(1)*(1)
    mn31 (mout RNb net426 VSS) nfet_01v8_lvt w=(425n) l=150n m=(1)*(1)
    mn40 (n35 CKbb mout VSS) nfet_01v8_lvt w=(425n) l=150n m=(1)*(1)
    mn30 (net426 SN VSS VSS) nfet_01v8_lvt w=(425n) l=150n m=(1)*(1)
ends DFFSRX1_HS

// sky130_scl_9T_HS/XNOR2X4_HS/schematic
subckt XNOR2X4_HS A B VDD VSS Y
    mp0 (n1 A VDD VDD) pfet_01v8 w=1.13u l=150n m=1
    mp4 (n1 n2 n0 VDD) pfet_01v8 w=(1.46u) l=150n m=(1)*(1)
    mp2 (net112 n1 VDD VDD) pfet_01v8 w=1.13u l=150n m=1
    mp1 (n2 B VDD VDD) pfet_01v8 w=(780n) l=150n m=(1)*(1)
    mp3 (n0 B net112 VDD) pfet_01v8 w=(1.46u) l=150n m=(1)*(1)
    mp5 (Y n0 VDD VDD) pfet_01v8 w=1.13u l=150n m=1
    mn1 (n2 B VSS VSS) nfet_01v8_lvt w=(425n) l=150n m=(1)*(1)
    mn2 (net145 n1 VSS VSS) nfet_01v8_lvt w=(760n) l=150n m=(1)*(1)
    mn3 (n0 n2 net145 VSS) nfet_01v8_lvt w=(760n) l=150n m=(1)*(1)
    mn5 (Y n0 VSS VSS) nfet_01v8_lvt w=(760n) l=150n m=(1)*(4)
    mn0 (n1 A VSS VSS) nfet_01v8_lvt w=(425n) l=150n m=(1)*(1)
    mn4 (n0 B n1 VSS) nfet_01v8_lvt w=(760n) l=150n m=(1)*(1)
ends XNOR2X4_HS

// sky130_scl_9T_HS/NAND4X2_HS/schematic
subckt NAND4X2_HS A B C D VDD VSS Y
    mp3 (Y D VDD VDD) pfet_01v8 w=(1.46u) l=150n m=(1)*(2)
    mp2 (Y C VDD VDD) pfet_01v8 w=(1.46u) l=150n m=(1)*(2)
    mp1 (Y B VDD VDD) pfet_01v8 w=(1.46u) l=150n m=(1)*(2)
    mp0 (Y A VDD VDD) pfet_01v8 w=1.13u l=150n m=2
    mn1 (n1 B n2 VSS) nfet_01v8_lvt w=(760n) l=150n m=(1)*(2)
    mn3 (Y D n0 VSS) nfet_01v8_lvt w=(760n) l=150n m=(1)*(2)
    mn2 (n0 C n1 VSS) nfet_01v8_lvt w=(760n) l=150n m=(1)*(2)
    mn0 (n2 A VSS VSS) nfet_01v8_lvt w=(760n) l=150n m=(1)*(2)
ends NAND4X2_HS

// sky130_scl_9T_HS/DLY1X4_HS/schematic
subckt DLY1X4_HS A VDD VSS Y
    mp2 (n1 VSS n5 VDD) pfet_01v8 w=(780n) l=150n m=(1)*(1)
    mp1 (n5 n0 VDD VDD) pfet_01v8 w=(780n) l=150n m=(1)*(1)
    mp4 (Y n2 VDD VDD) pfet_01v8 w=1.13u l=150n m=1
    mp0 (n0 A VDD VDD) pfet_01v8 w=1.13u l=150n m=1
    mp3 (n2 n1 VDD VDD) pfet_01v8 w=1.13u l=150n m=1
    mn2 (n1 VDD n4 VSS) nfet_01v8_lvt w=(425n) l=150n m=(1)*(1)
    mn1 (n4 n0 VSS VSS) nfet_01v8_lvt w=(425n) l=150n m=(1)*(1)
    mn4 (Y n2 VSS VSS) nfet_01v8_lvt w=(760n) l=150n m=(1)*(4)
    mn0 (n0 A VSS VSS) nfet_01v8_lvt w=(425n) l=150n m=(1)*(1)
    mn3 (n2 n1 VSS VSS) nfet_01v8_lvt w=(760n) l=150n m=(1)*(1)
ends DLY1X4_HS

// sky130_scl_9T_HS/OAI21X2_HS/schematic
subckt OAI21X2_HS A0 A1 B0 VDD VSS Y
    mp0 (n1 A0 VDD VDD) pfet_01v8 w=(1.46u) l=150n m=(1)*(2)
    mp2 (Y B0 VDD VDD) pfet_01v8 w=(1.46u) l=150n m=(1)*(2)
    mp1 (Y A1 n1 VDD) pfet_01v8 w=1.13u l=150n m=2
    mn2 (Y B0 n0 VSS) nfet_01v8_lvt w=(760n) l=150n m=(1)*(2)
    mn1 (n0 A1 VSS VSS) nfet_01v8_lvt w=(760n) l=150n m=(1)*(2)
    mn0 (n0 A0 VSS VSS) nfet_01v8_lvt w=(760n) l=150n m=(1)*(2)
ends OAI21X2_HS

// sky130_scl_9T_HS/ADDHX1_HS/schematic
subckt ADDHX1_HS A B CO S VDD VSS
    mp8 (CO COb VDD VDD) pfet_01v8 w=(1.46u) l=150n m=(1)*(1)
    mp5 (S Sb VDD VDD) pfet_01v8 w=625n l=150n m=1
    mp2 (n3 n0 VDD VDD) pfet_01v8 w=(780n) l=150n m=(1)*(1)
    mp3 (Sb n1 n3 VDD) pfet_01v8 w=625n l=150n m=1
    mp4 (Sb B n0 VDD) pfet_01v8 w=(780n) l=150n m=(1)*(1)
    mp1 (n1 B VDD VDD) pfet_01v8 w=(780n) l=150n m=(1)*(1)
    mp7 (COb B VDD VDD) pfet_01v8 w=(780n) l=150n m=(1)*(1)
    mp0 (n0 A VDD VDD) pfet_01v8 w=(780n) l=150n m=(1)*(1)
    mp6 (COb A VDD VDD) pfet_01v8 w=(780n) l=150n m=(1)*(1)
    mn8 (CO COb VSS VSS) nfet_01v8_lvt w=(760n) l=150n m=(1)*(1)
    mn7 (COb B n4 VSS) nfet_01v8_lvt w=(425n) l=150n m=(1)*(1)
    mn6 (n4 A VSS VSS) nfet_01v8_lvt w=(425n) l=150n m=(1)*(1)
    mn5 (S Sb VSS VSS) nfet_01v8_lvt w=(760n) l=150n m=(1)*(1)
    mn3 (Sb B n2 VSS) nfet_01v8_lvt w=(425n) l=150n m=(1)*(1)
    mn2 (n2 n0 VSS VSS) nfet_01v8_lvt w=(425n) l=150n m=(1)*(1)
    mn1 (n1 B VSS VSS) nfet_01v8_lvt w=(425n) l=150n m=(1)*(1)
    mn4 (Sb n1 n0 VSS) nfet_01v8_lvt w=(425n) l=150n m=(1)*(1)
    mn0 (n0 A VSS VSS) nfet_01v8_lvt w=(425n) l=150n m=(1)*(1)
ends ADDHX1_HS

// sky130_scl_9T_HS/SDFFSRX4_HS/schematic
subckt SDFFSRX4_HS CK D Q QN RN SE SI SN VDD VSS
    mp14 (Db SEb n3 VDD) pfet_01v8 w=(780n) l=150n m=(1)*(1)
    mp13 (n3 SI VDD VDD) pfet_01v8 w=(780n) l=150n m=(1)*(1)
    mp12 (Db SE n1 VDD) pfet_01v8 w=1.13u l=150n m=4
    mp11 (n1 D VDD VDD) pfet_01v8 w=(780n) l=150n m=(1)*(1)
    mp52 (n11 qbint n9 VDD) pfet_01v8 w=(780n) l=150n m=(1)*(1)
    mp51 (n9 RNb VDD VDD) pfet_01v8 w=(780n) l=150n m=(1)*(1)
    mp57 (QN net573 VDD VDD) pfet_01v8 w=1.13u l=150n m=4
    mp55 (Q qbint VDD VDD) pfet_01v8 w=(1.46u) l=150n m=(1)*(4)
    mp36 (n20 CKb n7 VDD) pfet_01v8 w=(780n) l=150n m=(1)*(1)
    mp35 (n7 mout VDD VDD) pfet_01v8 w=(780n) l=150n m=(1)*(1)
    mp32 (mout n20 n5 VDD) pfet_01v8 w=(780n) l=150n m=(1)*(1)
    mp31 (n5 RNb VDD VDD) pfet_01v8 w=(780n) l=150n m=(1)*(1)
    mp22 (RNb RN VDD VDD) pfet_01v8 w=(780n) l=150n m=(1)*(1)
    mp20 (CKb CK VDD VDD) pfet_01v8 w=(780n) l=150n m=(1)*(1)
    mp21 (CKbb CKb VDD VDD) pfet_01v8 w=(780n) l=150n m=(1)*(1)
    mp45 (qbint n35 VDD VDD) pfet_01v8 w=625n l=150n m=1
    mp30 (mout SN VDD VDD) pfet_01v8 w=(780n) l=150n m=(1)*(1)
    mp25 (n20 CKbb Db VDD) pfet_01v8 w=(780n) l=150n m=(1)*(1)
    mp56 (net573 qbint VDD VDD) pfet_01v8 w=1.13u l=150n m=4
    mp40 (n35 CKb mout VDD) pfet_01v8 w=(780n) l=150n m=(1)*(1)
    mp53 (n35 CKbb n11 VDD) pfet_01v8 w=(780n) l=150n m=(1)*(1)
    mp50 (n11 SN VDD VDD) pfet_01v8 w=(780n) l=150n m=(1)*(1)
    mp10 (SEb SE VDD VDD) pfet_01v8 w=(780n) l=150n m=(1)*(1)
    mn13 (n2 SI VSS VSS) nfet_01v8_lvt w=(425n) l=150n m=(1)*(1)
    mn14 (Db SE n2 VSS) nfet_01v8_lvt w=(425n) l=150n m=(1)*(1)
    mn12 (Db SEb n0 VSS) nfet_01v8_lvt w=(425n) l=150n m=(1)*(1)
    mn11 (n0 D VSS VSS) nfet_01v8_lvt w=(425n) l=150n m=(1)*(1)
    mn57 (QN net573 VSS VSS) nfet_01v8_lvt w=(760n) l=150n m=(1)*(4)
    mn55 (Q qbint VSS VSS) nfet_01v8_lvt w=(760n) l=150n m=(1)*(4)
    mn35 (n6 mout VSS VSS) nfet_01v8_lvt w=(425n) l=150n m=(1)*(1)
    mn36 (n20 CKbb n6 VSS) nfet_01v8_lvt w=(425n) l=150n m=(1)*(1)
    mn22 (RNb RN VSS VSS) nfet_01v8_lvt w=(425n) l=150n m=(1)*(1)
    mn20 (CKb CK VSS VSS) nfet_01v8_lvt w=(425n) l=150n m=(1)*(1)
    mn10 (SEb SE VSS VSS) nfet_01v8_lvt w=(425n) l=150n m=(1)*(1)
    mn56 (net573 qbint VSS VSS) nfet_01v8_lvt w=(760n) l=150n m=(1)*(1)
    mn25 (Db CKb n20 VSS) nfet_01v8_lvt w=(425n) l=150n m=(1)*(1)
    mn32 (mout n20 n4 VSS) nfet_01v8_lvt w=(425n) l=150n m=(1)*(1)
    mn53 (n35 CKb n10 VSS) nfet_01v8_lvt w=(425n) l=150n m=(1)*(1)
    mn30 (n4 SN VSS VSS) nfet_01v8_lvt w=(425n) l=150n m=(1)*(1)
    mn50 (n8 SN VSS VSS) nfet_01v8_lvt w=(425n) l=150n m=(1)*(1)
    mn51 (n10 RNb n8 VSS) nfet_01v8_lvt w=(425n) l=150n m=(1)*(1)
    mn40 (n35 CKbb mout VSS) nfet_01v8_lvt w=(425n) l=150n m=(1)*(1)
    mn31 (mout RNb n4 VSS) nfet_01v8_lvt w=(425n) l=150n m=(1)*(1)
    mn21 (CKbb CKb VSS VSS) nfet_01v8_lvt w=(425n) l=150n m=(1)*(1)
    mn52 (n10 qbint n8 VSS) nfet_01v8_lvt w=(425n) l=150n m=(1)*(1)
    mn45 (qbint n35 VSS VSS) nfet_01v8_lvt w=(600n) l=150n m=(1)*(2)
ends SDFFSRX4_HS

// sky130_scl_9T_HS/OAI21X1_HS/schematic
subckt OAI21X1_HS A0 A1 B0 VDD VSS Y
    mp0 (n1 A0 VDD VDD) pfet_01v8 w=(1.46u) l=150n m=(1)*(1)
    mp2 (Y B0 VDD VDD) pfet_01v8 w=(1.46u) l=150n m=(1)*(1)
    mp1 (Y A1 n1 VDD) pfet_01v8 w=1.13u l=150n m=1
    mn2 (Y B0 n0 VSS) nfet_01v8_lvt w=(760n) l=150n m=(1)*(1)
    mn1 (n0 A1 VSS VSS) nfet_01v8_lvt w=(760n) l=150n m=(1)*(1)
    mn0 (n0 A0 VSS VSS) nfet_01v8_lvt w=(760n) l=150n m=(1)*(1)
ends OAI21X1_HS

// sky130_scl_9T_HS/NAND4X1_HS/schematic
subckt NAND4X1_HS A B C D VDD VSS Y
    mp3 (Y D VDD VDD) pfet_01v8 w=(1.46u) l=150n m=(1)*(1)
    mp2 (Y C VDD VDD) pfet_01v8 w=(1.46u) l=150n m=(1)*(1)
    mp1 (Y B VDD VDD) pfet_01v8 w=(1.46u) l=150n m=(1)*(1)
    mp0 (Y A VDD VDD) pfet_01v8 w=1.13u l=150n m=1
    mn1 (n1 B n2 VSS) nfet_01v8_lvt w=(760n) l=150n m=(1)*(1)
    mn3 (Y D n0 VSS) nfet_01v8_lvt w=(760n) l=150n m=(1)*(1)
    mn2 (n0 C n1 VSS) nfet_01v8_lvt w=(760n) l=150n m=(1)*(1)
    mn0 (n2 A VSS VSS) nfet_01v8_lvt w=(760n) l=150n m=(1)*(1)
ends NAND4X1_HS

// sky130_scl_9T_HS/BUFX2_HS/schematic
subckt BUFX2_HS A VDD VSS Y
    mp1 (Y n0 VDD VDD) pfet_01v8 w=1.13u l=150n m=2
    mp0 (n0 A VDD VDD) pfet_01v8 w=1.13u l=150n m=2
    mn1 (VSS n0 Y VSS) nfet_01v8_lvt w=(760n) l=150n m=(1)*(2)
    mn0 (VSS A n0 VSS) nfet_01v8_lvt w=(425n) l=150n m=(1)*(1)
ends BUFX2_HS

// sky130_scl_9T_HS/DFFSX4_HS/schematic
subckt DFFSX4_HS CK D Q QN SN VDD VSS
    mp26 (n20 CKbb n22 VDD) pfet_01v8 w=(780n) l=150n m=(1)*(1)
    mp25 (n22 D VDD VDD) pfet_01v8 w=(780n) l=150n m=(1)*(1)
    mp57 (QN net331 VDD VDD) pfet_01v8 w=(1.46u) l=150n m=(1)*(4)
    mp55 (Q qbint VDD VDD) pfet_01v8 w=(1.46u) l=150n m=(1)*(4)
    mp36 (n20 CKb n31 VDD) pfet_01v8 w=(780n) l=150n m=(1)*(1)
    mp35 (n31 mout VDD VDD) pfet_01v8 w=(780n) l=150n m=(1)*(1)
    mp20 (CKb CK VDD VDD) pfet_01v8 w=(780n) l=150n m=(1)*(1)
    mp31 (mout n20 VDD VDD) pfet_01v8 w=(780n) l=150n m=(1)*(1)
    mp40 (n35 CKb mout VDD) pfet_01v8 w=(780n) l=150n m=(1)*(1)
    mp56 (net331 qbint VDD VDD) pfet_01v8 w=(1.46u) l=150n m=(1)*(1)
    mp45 (qbint n35 VDD VDD) pfet_01v8 w=(1.12u) l=150n m=(1)*(2)
    mp52 (n35 CKbb n41 VDD) pfet_01v8 w=(780n) l=150n m=(1)*(1)
    mp21 (CKbb CKb VDD VDD) pfet_01v8 w=(780n) l=150n m=(1)*(1)
    mp30 (mout SN VDD VDD) pfet_01v8 w=(780n) l=150n m=(1)*(1)
    mp51 (n41 qbint VDD VDD) pfet_01v8 w=(780n) l=150n m=(1)*(1)
    mp50 (n41 SN VDD VDD) pfet_01v8 w=(780n) l=150n m=(1)*(1)
    mn51 (n40 qbint n42 VSS) nfet_01v8_lvt w=(425n) l=150n m=(1)*(1)
    mn52 (n35 CKb n40 VSS) nfet_01v8_lvt w=(425n) l=150n m=(1)*(1)
    mn50 (n42 SN VSS VSS) nfet_01v8_lvt w=(425n) l=150n m=(1)*(1)
    mn26 (n20 CKb n21 VSS) nfet_01v8_lvt w=(425n) l=150n m=(1)*(1)
    mn25 (n21 D VSS VSS) nfet_01v8_lvt w=(425n) l=150n m=(1)*(1)
    mn57 (QN net331 VSS VSS) nfet_01v8_lvt w=(760n) l=150n m=(1)*(4)
    mn55 (Q qbint VSS VSS) nfet_01v8_lvt w=(760n) l=150n m=(1)*(4)
    mn30 (n25 SN VSS VSS) nfet_01v8_lvt w=(425n) l=150n m=(1)*(1)
    mn31 (mout n20 n25 VSS) nfet_01v8_lvt w=(425n) l=150n m=(1)*(1)
    mn35 (n20 CKbb n30 VSS) nfet_01v8_lvt w=(425n) l=150n m=(1)*(1)
    mn36 (n30 mout VSS VSS) nfet_01v8_lvt w=(425n) l=150n m=(1)*(1)
    mn56 (net331 qbint VSS VSS) nfet_01v8_lvt w=(760n) l=150n m=(1)*(1)
    mn20 (CKb CK VSS VSS) nfet_01v8_lvt w=(425n) l=150n m=(1)*(1)
    mn21 (CKbb CKb VSS VSS) nfet_01v8_lvt w=(425n) l=150n m=(1)*(1)
    mn45 (qbint n35 VSS VSS) nfet_01v8_lvt w=(600n) l=150n m=(1)*(2)
    mn40 (n35 CKbb mout VSS) nfet_01v8_lvt w=(425n) l=150n m=(1)*(1)
ends DFFSX4_HS

// sky130_scl_9T_HS/DLY1X1_HS/schematic
subckt DLY1X1_HS A VDD VSS Y
    mp2 (n1 VSS n5 VDD) pfet_01v8 w=625n l=150n m=1
    mp1 (n5 n0 VDD VDD) pfet_01v8 w=(780n) l=150n m=(1)*(1)
    mp4 (Y n2 VDD VDD) pfet_01v8 w=625n l=150n m=1
    mp0 (n0 A VDD VDD) pfet_01v8 w=(780n) l=150n m=(1)*(1)
    mp3 (n2 n1 VDD VDD) pfet_01v8 w=(780n) l=150n m=(1)*(1)
    mn2 (n1 VDD n4 VSS) nfet_01v8_lvt w=(425n) l=150n m=(1)*(1)
    mn1 (n4 n0 VSS VSS) nfet_01v8_lvt w=(425n) l=150n m=(1)*(1)
    mn4 (Y n2 VSS VSS) nfet_01v8_lvt w=(760n) l=150n m=(1)*(1)
    mn0 (n0 A VSS VSS) nfet_01v8_lvt w=(425n) l=150n m=(1)*(1)
    mn3 (n2 n1 VSS VSS) nfet_01v8_lvt w=(425n) l=150n m=(1)*(1)
ends DLY1X1_HS

// sky130_scl_9T_HS/INVX8_HS/schematic
subckt INVX8_HS A VDD VSS Y
    mp0 (Y A VDD VDD) pfet_01v8 w=(1.46u) l=150n m=(1)*(8)
    mn0 (Y A VSS VSS) nfet_01v8_lvt w=(760n) l=150n m=(1)*(8)
ends INVX8_HS

// sky130_scl_9T_HS/AND2X1_HS/schematic
subckt AND2X1_HS A B VDD VSS Y
    mp1 (n0 B VDD VDD) pfet_01v8 w=(780n) l=150n m=(1)*(1)
    mp0 (n0 A VDD VDD) pfet_01v8 w=625n l=150n m=1
    mp2 (Y n0 VDD VDD) pfet_01v8 w=625n l=150n m=1
    mn2 (Y n0 VSS VSS) nfet_01v8_lvt w=(760n) l=150n m=(1)*(1)
    mn0 (net127 B VSS VSS) nfet_01v8_lvt w=(425n) l=150n m=(1)*(1)
    mn1 (n0 A net127 VSS) nfet_01v8_lvt w=(425n) l=150n m=(1)*(1)
ends AND2X1_HS

// sky130_scl_9T_HS/XNOR2X1_HS/schematic
subckt XNOR2X1_HS A B VDD VSS Y
    mp0 (n1 A VDD VDD) pfet_01v8 w=1.13u l=150n m=1
    mp4 (n1 n2 n0 VDD) pfet_01v8 w=(780n) l=150n m=(1)*(1)
    mp2 (net112 n1 VDD VDD) pfet_01v8 w=(780n) l=150n m=(1)*(1)
    mp1 (n2 B VDD VDD) pfet_01v8 w=(780n) l=150n m=(1)*(1)
    mp3 (n0 B net112 VDD) pfet_01v8 w=(780n) l=150n m=(1)*(1)
    mp5 (Y n0 VDD VDD) pfet_01v8 w=1.13u l=150n m=1
    mn1 (n2 B VSS VSS) nfet_01v8_lvt w=(425n) l=150n m=(1)*(1)
    mn2 (net145 n1 VSS VSS) nfet_01v8_lvt w=(425n) l=150n m=(1)*(1)
    mn3 (n0 n2 net145 VSS) nfet_01v8_lvt w=(425n) l=150n m=(1)*(1)
    mn5 (Y n0 VSS VSS) nfet_01v8_lvt w=(760n) l=150n m=(1)*(1)
    mn0 (n1 A VSS VSS) nfet_01v8_lvt w=(425n) l=150n m=(1)*(1)
    mn4 (n0 B n1 VSS) nfet_01v8_lvt w=(425n) l=150n m=(1)*(1)
ends XNOR2X1_HS

// sky130_scl_9T_HS/DFFSRX4_HS/schematic
subckt DFFSRX4_HS CK D Q QN RN SN VDD VSS
    mp26 (n20 CKbb n22 VDD) pfet_01v8 w=1.13u l=150n m=1
    mp25 (n22 D VDD VDD) pfet_01v8 w=(780n) l=150n m=(1)*(1)
    mp52 (n41 qbint n43 VDD) pfet_01v8 w=(780n) l=150n m=(1)*(1)
    mp51 (n43 RNb VDD VDD) pfet_01v8 w=(780n) l=150n m=(1)*(1)
    mp57 (QN qint VDD VDD) pfet_01v8 w=(1.46u) l=150n m=(1)*(4)
    mp55 (Q qbint VDD VDD) pfet_01v8 w=1.13u l=150n m=1
    mp36 (n20 CKb n31 VDD) pfet_01v8 w=(780n) l=150n m=(1)*(1)
    mp35 (n31 mout VDD VDD) pfet_01v8 w=(780n) l=150n m=(1)*(1)
    mp32 (mout n20 net402 VDD) pfet_01v8 w=(780n) l=150n m=(1)*(1)
    mp31 (net402 RNb VDD VDD) pfet_01v8 w=(780n) l=150n m=(1)*(1)
    mp22 (RNb RN VDD VDD) pfet_01v8 w=(780n) l=150n m=(1)*(1)
    mp20 (CKb CK VDD VDD) pfet_01v8 w=(780n) l=150n m=(1)*(1)
    mp53 (n35 CKbb n41 VDD) pfet_01v8 w=1.13u l=150n m=1
    mp50 (n41 SN VDD VDD) pfet_01v8 w=(780n) l=150n m=(1)*(1)
    mp45 (qbint n35 VDD VDD) pfet_01v8 w=(1.25u) l=150n m=(1)*(2)
    mp56 (qint qbint VDD VDD) pfet_01v8 w=(1.46u) l=150n m=(1)*(1)
    mp21 (CKbb CKb VDD VDD) pfet_01v8 w=(780n) l=150n m=(1)*(1)
    mp30 (mout SN VDD VDD) pfet_01v8 w=(780n) l=150n m=(1)*(1)
    mp40 (n35 CKb mout VDD) pfet_01v8 w=(780n) l=150n m=(1)*(1)
    mn26 (n20 CKb n21 VSS) nfet_01v8_lvt w=(425n) l=150n m=(1)*(1)
    mn25 (n21 D VSS VSS) nfet_01v8_lvt w=(425n) l=150n m=(1)*(1)
    mn57 (QN qint VSS VSS) nfet_01v8_lvt w=(760n) l=150n m=(1)*(4)
    mn55 (Q qbint VSS VSS) nfet_01v8_lvt w=(760n) l=150n m=(1)*(4)
    mn35 (n30 mout VSS VSS) nfet_01v8_lvt w=(425n) l=150n m=(1)*(1)
    mn36 (n20 CKbb n30 VSS) nfet_01v8_lvt w=(425n) l=150n m=(1)*(1)
    mn22 (RNb RN VSS VSS) nfet_01v8_lvt w=(425n) l=150n m=(1)*(1)
    mn20 (CKb CK VSS VSS) nfet_01v8_lvt w=(425n) l=150n m=(1)*(1)
    mn45 (qbint n35 VSS VSS) nfet_01v8_lvt w=(600n) l=150n m=(1)*(2)
    mn56 (qint qbint VSS VSS) nfet_01v8_lvt w=(760n) l=150n m=(1)*(1)
    mn52 (n40 qbint n42 VSS) nfet_01v8_lvt w=(425n) l=150n m=(1)*(1)
    mn51 (n40 RNb n42 VSS) nfet_01v8_lvt w=(425n) l=150n m=(1)*(1)
    mn50 (n42 SN VSS VSS) nfet_01v8_lvt w=(425n) l=150n m=(1)*(1)
    mn53 (n35 CKb n40 VSS) nfet_01v8_lvt w=(425n) l=150n m=(1)*(1)
    mn21 (CKbb CKb VSS VSS) nfet_01v8_lvt w=(425n) l=150n m=(1)*(1)
    mn32 (mout n20 net426 VSS) nfet_01v8_lvt w=(425n) l=150n m=(1)*(1)
    mn31 (mout RNb net426 VSS) nfet_01v8_lvt w=(425n) l=150n m=(1)*(1)
    mn40 (n35 CKbb mout VSS) nfet_01v8_lvt w=(425n) l=150n m=(1)*(1)
    mn30 (net426 SN VSS VSS) nfet_01v8_lvt w=(425n) l=150n m=(1)*(1)
ends DFFSRX4_HS

// sky130_scl_9T_HS/BUFX4_HS/schematic
subckt BUFX4_HS A VDD VSS Y
    mp1 (Y n0 VDD VDD) pfet_01v8 w=625n l=150n m=1
    mp0 (n0 A VDD VDD) pfet_01v8 w=625n l=150n m=1
    mn1 (VSS n0 Y VSS) nfet_01v8_lvt w=(760n) l=150n m=(1)*(4)
    mn0 (VSS A n0 VSS) nfet_01v8_lvt w=(760n) l=150n m=(1)*(1)
ends BUFX4_HS

// sky130_scl_9T_HS/DFFSX1_HS/schematic
subckt DFFSX1_HS CK D Q QN SN VDD VSS
    mp26 (n20 CKbb n22 VDD) pfet_01v8 w=625n l=150n m=1
    mp25 (n22 D VDD VDD) pfet_01v8 w=(780n) l=150n m=(1)*(1)
    mp57 (QN net331 VDD VDD) pfet_01v8 w=(1.46u) l=150n m=(1)*(1)
    mp55 (Q qbint VDD VDD) pfet_01v8 w=625n l=150n m=1
    mp36 (n20 CKb n31 VDD) pfet_01v8 w=(780n) l=150n m=(1)*(1)
    mp35 (n31 mout VDD VDD) pfet_01v8 w=(780n) l=150n m=(1)*(1)
    mp20 (CKb CK VDD VDD) pfet_01v8 w=(780n) l=150n m=(1)*(1)
    mp31 (mout n20 VDD VDD) pfet_01v8 w=(780n) l=150n m=(1)*(1)
    mp40 (n35 CKb mout VDD) pfet_01v8 w=(780n) l=150n m=(1)*(1)
    mp56 (net331 qbint VDD VDD) pfet_01v8 w=(780n) l=150n m=(1)*(1)
    mp45 (qbint n35 VDD VDD) pfet_01v8 w=(780n) l=150n m=(1)*(1)
    mp52 (n35 CKbb n41 VDD) pfet_01v8 w=(780n) l=150n m=(1)*(1)
    mp21 (CKbb CKb VDD VDD) pfet_01v8 w=(780n) l=150n m=(1)*(1)
    mp30 (mout SN VDD VDD) pfet_01v8 w=(780n) l=150n m=(1)*(1)
    mp51 (n41 qbint VDD VDD) pfet_01v8 w=(780n) l=150n m=(1)*(1)
    mp50 (n41 SN VDD VDD) pfet_01v8 w=(780n) l=150n m=(1)*(1)
    mn51 (n40 qbint n42 VSS) nfet_01v8_lvt w=(425n) l=150n m=(1)*(1)
    mn52 (n35 CKb n40 VSS) nfet_01v8_lvt w=(425n) l=150n m=(1)*(1)
    mn50 (n42 SN VSS VSS) nfet_01v8_lvt w=(425n) l=150n m=(1)*(1)
    mn26 (n20 CKb n21 VSS) nfet_01v8_lvt w=(425n) l=150n m=(1)*(1)
    mn25 (n21 D VSS VSS) nfet_01v8_lvt w=(425n) l=150n m=(1)*(1)
    mn57 (QN net331 VSS VSS) nfet_01v8_lvt w=(760n) l=150n m=(1)*(1)
    mn55 (Q qbint VSS VSS) nfet_01v8_lvt w=(760n) l=150n m=(1)*(1)
    mn30 (n25 SN VSS VSS) nfet_01v8_lvt w=(425n) l=150n m=(1)*(1)
    mn31 (mout n20 n25 VSS) nfet_01v8_lvt w=(425n) l=150n m=(1)*(1)
    mn35 (n20 CKbb n30 VSS) nfet_01v8_lvt w=(425n) l=150n m=(1)*(1)
    mn36 (n30 mout VSS VSS) nfet_01v8_lvt w=(425n) l=150n m=(1)*(1)
    mn56 (net331 qbint VSS VSS) nfet_01v8_lvt w=(425n) l=150n m=(1)*(1)
    mn20 (CKb CK VSS VSS) nfet_01v8_lvt w=(425n) l=150n m=(1)*(1)
    mn21 (CKbb CKb VSS VSS) nfet_01v8_lvt w=(425n) l=150n m=(1)*(1)
    mn45 (qbint n35 VSS VSS) nfet_01v8_lvt w=(425n) l=150n m=(1)*(1)
    mn40 (n35 CKbb mout VSS) nfet_01v8_lvt w=(425n) l=150n m=(1)*(1)
ends DFFSX1_HS

// sky130_scl_9T_HS/NAND4X4_HS/schematic
subckt NAND4X4_HS A B C D VDD VSS Y
    mp3 (Y D VDD VDD) pfet_01v8 w=(1.46u) l=150n m=(1)*(4)
    mp2 (Y C VDD VDD) pfet_01v8 w=(1.46u) l=150n m=(1)*(4)
    mp1 (Y B VDD VDD) pfet_01v8 w=(1.46u) l=150n m=(1)*(4)
    mp0 (Y A VDD VDD) pfet_01v8 w=1.13u l=150n m=4
    mn1 (n1 B n2 VSS) nfet_01v8_lvt w=(760n) l=150n m=(1)*(4)
    mn3 (Y D n0 VSS) nfet_01v8_lvt w=(760n) l=150n m=(1)*(4)
    mn2 (n0 C n1 VSS) nfet_01v8_lvt w=(760n) l=150n m=(1)*(4)
    mn0 (n2 A VSS VSS) nfet_01v8_lvt w=(760n) l=150n m=(1)*(4)
ends NAND4X4_HS

// sky130_scl_9T_HS/XNOR2X2_HS/schematic
subckt XNOR2X2_HS A B VDD VSS Y
    mp0 (n1 A VDD VDD) pfet_01v8 w=1.13u l=150n m=2
    mp4 (n1 n2 n0 VDD) pfet_01v8 w=(780n) l=150n m=(1)*(1)
    mp2 (net112 n1 VDD VDD) pfet_01v8 w=(780n) l=150n m=(1)*(1)
    mp1 (n2 B VDD VDD) pfet_01v8 w=(780n) l=150n m=(1)*(1)
    mp3 (n0 B net112 VDD) pfet_01v8 w=(780n) l=150n m=(1)*(1)
    mp5 (Y n0 VDD VDD) pfet_01v8 w=1.13u l=150n m=2
    mn1 (n2 B VSS VSS) nfet_01v8_lvt w=(425n) l=150n m=(1)*(1)
    mn2 (net145 n1 VSS VSS) nfet_01v8_lvt w=(425n) l=150n m=(1)*(1)
    mn3 (n0 n2 net145 VSS) nfet_01v8_lvt w=(425n) l=150n m=(1)*(1)
    mn5 (Y n0 VSS VSS) nfet_01v8_lvt w=(760n) l=150n m=(1)*(2)
    mn0 (n1 A VSS VSS) nfet_01v8_lvt w=(425n) l=150n m=(1)*(1)
    mn4 (n0 B n1 VSS) nfet_01v8_lvt w=(425n) l=150n m=(1)*(1)
ends XNOR2X2_HS

// sky130_scl_9T_HS/AND2X2_HS/schematic
subckt AND2X2_HS A B VDD VSS Y
    mp1 (n0 B VDD VDD) pfet_01v8 w=(780n) l=150n m=(1)*(1)
    mp0 (n0 A VDD VDD) pfet_01v8 w=625n l=150n m=1
    mp2 (Y n0 VDD VDD) pfet_01v8 w=625n l=150n m=1
    mn2 (Y n0 VSS VSS) nfet_01v8_lvt w=(760n) l=150n m=(1)*(2)
    mn0 (net73 A VSS VSS) nfet_01v8_lvt w=(425n) l=150n m=(1)*(1)
    mn1 (n0 B net73 VSS) nfet_01v8_lvt w=(425n) l=150n m=(1)*(1)
ends AND2X2_HS

// sky130_scl_9T_HS/SDFFSRX1_HS/schematic
subckt SDFFSRX1_HS CK D Q QN RN SE SI SN VDD VSS
    mp14 (Db SEb n3 VDD) pfet_01v8 w=(780n) l=150n m=(1)*(1)
    mp13 (n3 SI VDD VDD) pfet_01v8 w=(780n) l=150n m=(1)*(1)
    mp12 (Db SE n1 VDD) pfet_01v8 w=(780n) l=150n m=(1)*(1)
    mp11 (n1 D VDD VDD) pfet_01v8 w=(780n) l=150n m=(1)*(1)
    mp52 (n11 qbint n9 VDD) pfet_01v8 w=(780n) l=150n m=(1)*(1)
    mp51 (n9 RNb VDD VDD) pfet_01v8 w=(780n) l=150n m=(1)*(1)
    mp57 (QN net573 VDD VDD) pfet_01v8 w=(1.46u) l=150n m=(1)*(1)
    mp55 (Q qbint VDD VDD) pfet_01v8 w=625n l=150n m=1
    mp36 (n20 CKb n7 VDD) pfet_01v8 w=(780n) l=150n m=(1)*(1)
    mp35 (n7 mout VDD VDD) pfet_01v8 w=(780n) l=150n m=(1)*(1)
    mp32 (mout n20 n5 VDD) pfet_01v8 w=(780n) l=150n m=(1)*(1)
    mp31 (n5 RNb VDD VDD) pfet_01v8 w=(780n) l=150n m=(1)*(1)
    mp22 (RNb RN VDD VDD) pfet_01v8 w=(780n) l=150n m=(1)*(1)
    mp20 (CKb CK VDD VDD) pfet_01v8 w=(780n) l=150n m=(1)*(1)
    mp21 (CKbb CKb VDD VDD) pfet_01v8 w=(780n) l=150n m=(1)*(1)
    mp45 (qbint n35 VDD VDD) pfet_01v8 w=(780n) l=150n m=(1)*(1)
    mp30 (mout SN VDD VDD) pfet_01v8 w=(780n) l=150n m=(1)*(1)
    mp25 (n20 CKbb Db VDD) pfet_01v8 w=(780n) l=150n m=(1)*(1)
    mp56 (net573 qbint VDD VDD) pfet_01v8 w=(780n) l=150n m=(1)*(1)
    mp40 (n35 CKb mout VDD) pfet_01v8 w=(780n) l=150n m=(1)*(1)
    mp53 (n35 CKbb n11 VDD) pfet_01v8 w=625n l=150n m=1
    mp50 (n11 SN VDD VDD) pfet_01v8 w=(780n) l=150n m=(1)*(1)
    mp10 (SEb SE VDD VDD) pfet_01v8 w=(780n) l=150n m=(1)*(1)
    mn13 (n2 SI VSS VSS) nfet_01v8_lvt w=(425n) l=150n m=(1)*(1)
    mn14 (Db SE n2 VSS) nfet_01v8_lvt w=(425n) l=150n m=(1)*(1)
    mn12 (Db SEb n0 VSS) nfet_01v8_lvt w=(425n) l=150n m=(1)*(1)
    mn11 (n0 D VSS VSS) nfet_01v8_lvt w=(425n) l=150n m=(1)*(1)
    mn57 (QN net573 VSS VSS) nfet_01v8_lvt w=(760n) l=150n m=(1)*(1)
    mn55 (Q qbint VSS VSS) nfet_01v8_lvt w=(760n) l=150n m=(1)*(1)
    mn35 (n6 mout VSS VSS) nfet_01v8_lvt w=(425n) l=150n m=(1)*(1)
    mn36 (n20 CKbb n6 VSS) nfet_01v8_lvt w=(425n) l=150n m=(1)*(1)
    mn22 (RNb RN VSS VSS) nfet_01v8_lvt w=(425n) l=150n m=(1)*(1)
    mn20 (CKb CK VSS VSS) nfet_01v8_lvt w=(425n) l=150n m=(1)*(1)
    mn10 (SEb SE VSS VSS) nfet_01v8_lvt w=(425n) l=150n m=(1)*(1)
    mn56 (net573 qbint VSS VSS) nfet_01v8_lvt w=(425n) l=150n m=(1)*(1)
    mn25 (Db CKb n20 VSS) nfet_01v8_lvt w=(425n) l=150n m=(1)*(1)
    mn32 (mout n20 n4 VSS) nfet_01v8_lvt w=(425n) l=150n m=(1)*(1)
    mn53 (n35 CKb n10 VSS) nfet_01v8_lvt w=(425n) l=150n m=(1)*(1)
    mn30 (n4 SN VSS VSS) nfet_01v8_lvt w=(425n) l=150n m=(1)*(1)
    mn50 (n8 SN VSS VSS) nfet_01v8_lvt w=(425n) l=150n m=(1)*(1)
    mn51 (n10 RNb n8 VSS) nfet_01v8_lvt w=(425n) l=150n m=(1)*(1)
    mn40 (n35 CKbb mout VSS) nfet_01v8_lvt w=(425n) l=150n m=(1)*(1)
    mn31 (mout RNb n4 VSS) nfet_01v8_lvt w=(425n) l=150n m=(1)*(1)
    mn21 (CKbb CKb VSS VSS) nfet_01v8_lvt w=(425n) l=150n m=(1)*(1)
    mn52 (n10 qbint n8 VSS) nfet_01v8_lvt w=(425n) l=150n m=(1)*(1)
    mn45 (qbint n35 VSS VSS) nfet_01v8_lvt w=(425n) l=150n m=(1)*(1)
ends SDFFSRX1_HS

// sky130_scl_9T_HS/CLKINVX4_HS/schematic
subckt CLKINVX4_HS A VDD VSS Y
    mp0 (Y A VDD VDD) pfet_01v8 w=(1.06u) l=150n m=(1)*(12)
    mn0 (Y A VSS VSS) nfet_01v8_lvt w=(760n) l=150n m=(1)*(4)
ends CLKINVX4_HS

// sky130_scl_9T_HS/NAND3X2_HS/schematic
subckt NAND3X2_HS A B C VDD VSS Y
    mp0 (Y A VDD VDD) pfet_01v8 w=(1.46u) l=150n m=(1)*(2)
    mp1 (Y B VDD VDD) pfet_01v8 w=(1.46u) l=150n m=(1)*(2)
    mp2 (Y C VDD VDD) pfet_01v8 w=1.13u l=150n m=1
    mn1 (n0 B n1 VSS) nfet_01v8_lvt w=(760n) l=150n m=(1)*(2)
    mn2 (Y C n0 VSS) nfet_01v8_lvt w=(760n) l=150n m=(1)*(2)
    mn0 (n1 A VSS VSS) nfet_01v8_lvt w=(760n) l=150n m=(1)*(2)
ends NAND3X2_HS

// sky130_scl_9T_HS/NOR2X2_HS/schematic
subckt NOR2X2_HS A B VDD VSS Y
    mp1 (Y B net41 VDD) pfet_01v8 w=1.13u l=150n m=2
    mp0 (net41 A VDD VDD) pfet_01v8 w=(1.46u) l=150n m=(1)*(2)
    mn1 (Y B VSS VSS) nfet_01v8_lvt w=(760n) l=150n m=(1)*(2)
    mn0 (Y A VSS VSS) nfet_01v8_lvt w=(760n) l=150n m=(1)*(2)
ends NOR2X2_HS

// sky130_scl_9T_HS/CLKBUFX8_HS/schematic
subckt CLKBUFX8_HS A VDD VSS Y
    mp1 (Y net44 VDD VDD) pfet_01v8 w=(1.06u) l=150n m=(1)*(16)
    mp0 (net44 A VDD VDD) pfet_01v8 w=(1.06u) l=150n m=(1)*(2)
    mn1 (Y net44 VSS VSS) nfet_01v8_lvt w=(760n) l=150n m=(1)*(8)
    mn0 (net44 A VSS VSS) nfet_01v8_lvt w=(760n) l=150n m=(1)*(2)
ends CLKBUFX8_HS

// sky130_scl_9T_HS/TBUFX1_HS/schematic
subckt TBUFX1_HS A OE VDD VSS Y
    mp2 (non OEb net127 VDD) pfet_01v8 w=(780n) l=150n m=(1)*(1)
    mp1 (net127 A VDD VDD) pfet_01v8 w=(780n) l=150n m=(1)*(1)
    mp5 (Y pon VDD VDD) pfet_01v8 w=1.13u l=150n m=1
    mp3 (pon A VDD VDD) pfet_01v8 w=(780n) l=150n m=(1)*(1)
    mp4 (pon OE VDD VDD) pfet_01v8 w=(780n) l=150n m=(1)*(1)
    mp0 (OEb OE VDD VDD) pfet_01v8 w=1.13u l=150n m=1
    mn5 (Y non VSS VSS) nfet_01v8_lvt w=(760n) l=150n m=(1)*(1)
    mn3 (net144 A VSS VSS) nfet_01v8_lvt w=(425n) l=150n m=(1)*(1)
    mn0 (OEb OE VSS VSS) nfet_01v8_lvt w=(425n) l=150n m=(1)*(1)
    mn4 (pon OE net144 VSS) nfet_01v8_lvt w=(425n) l=150n m=(1)*(1)
    mn2 (non OEb VSS VSS) nfet_01v8_lvt w=(425n) l=150n m=(1)*(1)
    mn1 (non A VSS VSS) nfet_01v8_lvt w=(425n) l=150n m=(1)*(1)
ends TBUFX1_HS

// sky130_scl_9T_HS/MX4X1_HS/schematic
subckt MX4X1_HS A B C D S0 S1 VDD VSS Y
    mp9 (n1 S0b n10 VDD) pfet_01v8 w=(780n) l=150n m=(1)*(1)
    mp8 (n10 D VDD VDD) pfet_01v8 w=(780n) l=150n m=(1)*(1)
    mp7 (n1 S0 n8 VDD) pfet_01v8 w=(780n) l=150n m=(1)*(1)
    mp6 (n8 C VDD VDD) pfet_01v8 w=(780n) l=150n m=(1)*(1)
    mp5 (n0 S0b n6 VDD) pfet_01v8 w=(780n) l=150n m=(1)*(1)
    mp4 (n6 B VDD VDD) pfet_01v8 w=(780n) l=150n m=(1)*(1)
    mp3 (n0 S0 n4 VDD) pfet_01v8 w=1.13u l=150n m=2
    mp2 (n4 A VDD VDD) pfet_01v8 w=(780n) l=150n m=(1)*(1)
    mp12 (Y n2 VDD VDD) pfet_01v8 w=1.13u l=150n m=2
    mp0 (S0b S0 VDD VDD) pfet_01v8 w=(780n) l=150n m=(1)*(1)
    mp10 (n2 S1 n0 VDD) pfet_01v8 w=(780n) l=150n m=(1)*(1)
    mp11 (n1 S1b n2 VDD) pfet_01v8 w=(780n) l=150n m=(1)*(1)
    mp1 (S1b S1 VDD VDD) pfet_01v8 w=(780n) l=150n m=(1)*(1)
    mn9 (n1 S0 n9 VSS) nfet_01v8_lvt w=(425n) l=150n m=(1)*(1)
    mn6 (n7 C VSS VSS) nfet_01v8_lvt w=(425n) l=150n m=(1)*(1)
    mn7 (n1 S0b n7 VSS) nfet_01v8_lvt w=(425n) l=150n m=(1)*(1)
    mn4 (n5 B VSS VSS) nfet_01v8_lvt w=(425n) l=150n m=(1)*(1)
    mn5 (n0 S0 n5 VSS) nfet_01v8_lvt w=(425n) l=150n m=(1)*(1)
    mn3 (n0 S0b n3 VSS) nfet_01v8_lvt w=(425n) l=150n m=(1)*(1)
    mn2 (n3 A VSS VSS) nfet_01v8_lvt w=(425n) l=150n m=(1)*(1)
    mn12 (Y n2 VSS VSS) nfet_01v8_lvt w=(760n) l=150n m=(1)*(1)
    mn1 (S1b S1 VSS VSS) nfet_01v8_lvt w=(425n) l=150n m=(1)*(1)
    mn11 (n2 S1 n1 VSS) nfet_01v8_lvt w=(425n) l=150n m=(1)*(1)
    mn8 (n9 D VSS VSS) nfet_01v8_lvt w=(425n) l=150n m=(1)*(1)
    mn10 (n2 S1b n0 VSS) nfet_01v8_lvt w=(425n) l=150n m=(1)*(1)
    mn0 (S0b S0 VSS VSS) nfet_01v8_lvt w=(425n) l=150n m=(1)*(1)
ends MX4X1_HS

// sky130_scl_9T_HS/AOI211X1_HS/schematic
subckt AOI211X1_HS A0 A1 B0 C0 VDD VSS Y
    mp3 (Y C0 net82 VDD) pfet_01v8 w=(1.46u) l=150n m=(1)*(1)
    mp2 (net82 B0 net91 VDD) pfet_01v8 w=(1.46u) l=150n m=(1)*(1)
    mp1 (net91 A1 VDD VDD) pfet_01v8 w=(1.46u) l=150n m=(1)*(1)
    mp0 (net91 A0 VDD VDD) pfet_01v8 w=(1.46u) l=150n m=(1)*(1)
    mn2 (Y B0 VSS VSS) nfet_01v8_lvt w=(760n) l=150n m=(1)*(1)
    mn3 (Y C0 VSS VSS) nfet_01v8_lvt w=(760n) l=150n m=(1)*(1)
    mn1 (Y A1 net95 VSS) nfet_01v8_lvt w=(760n) l=150n m=(1)*(1)
    mn0 (net95 A0 VSS VSS) nfet_01v8_lvt w=(760n) l=150n m=(1)*(1)
ends AOI211X1_HS

// sky130_scl_9T_HS/OAI22X1_HS/schematic
subckt OAI22X1_HS A0 A1 B0 B1 VDD VSS Y
    mp3 (Y B1 net85 VDD) pfet_01v8 w=(1.46u) l=150n m=(1)*(1)
    mp1 (Y A1 net93 VDD) pfet_01v8 w=1.13u l=150n m=1
    mp0 (net93 A0 VDD VDD) pfet_01v8 w=(1.46u) l=150n m=(1)*(1)
    mp2 (net85 B0 VDD VDD) pfet_01v8 w=(1.46u) l=150n m=(1)*(1)
    mn0 (net102 A0 VSS VSS) nfet_01v8_lvt w=(760n) l=150n m=(1)*(1)
    mn3 (Y B1 net102 VSS) nfet_01v8_lvt w=(760n) l=150n m=(1)*(1)
    mn1 (net102 A1 VSS VSS) nfet_01v8_lvt w=(760n) l=150n m=(1)*(1)
    mn2 (Y B0 net102 VSS) nfet_01v8_lvt w=(760n) l=150n m=(1)*(1)
ends OAI22X1_HS

// sky130_scl_9T_HS/OAI211X1_HS/schematic
subckt OAI211X1_HS A0 A1 B0 C0 VDD VSS Y
    mp1 (Y A1 n2 VDD) pfet_01v8 w=(1.46u) l=150n m=(1)*(1)
    mp0 (n2 A0 VDD VDD) pfet_01v8 w=1.13u l=150n m=1
    mp3 (Y C0 VDD VDD) pfet_01v8 w=(1.46u) l=150n m=(1)*(1)
    mp2 (Y B0 VDD VDD) pfet_01v8 w=(1.46u) l=150n m=(1)*(1)
    mn1 (n0 A1 VSS VSS) nfet_01v8_lvt w=(760n) l=150n m=(1)*(1)
    mn0 (n0 A0 VSS VSS) nfet_01v8_lvt w=(760n) l=150n m=(1)*(1)
    mn2 (n1 B0 n0 VSS) nfet_01v8_lvt w=(760n) l=150n m=(1)*(1)
    mn3 (Y C0 n1 VSS) nfet_01v8_lvt w=(760n) l=150n m=(1)*(1)
ends OAI211X1_HS

// sky130_scl_9T_HS/SDFFSX4_HS/schematic
subckt SDFFSX4_HS CK D Q QN SE SI SN VDD VSS
    mp14 (Db SEb net441 VDD) pfet_01v8 w=(780n) l=150n m=(1)*(1)
    mp13 (net441 SI VDD VDD) pfet_01v8 w=(780n) l=150n m=(1)*(1)
    mp12 (Db SE net433 VDD) pfet_01v8 w=(780n) l=150n m=(1)*(1)
    mp11 (net433 D VDD VDD) pfet_01v8 w=(780n) l=150n m=(1)*(1)
    mp57 (QN net492 VDD VDD) pfet_01v8 w=(1.46u) l=150n m=(1)*(4)
    mp55 (Q qbint VDD VDD) pfet_01v8 w=1.13u l=150n m=1
    mp36 (n20 CKb net417 VDD) pfet_01v8 w=(780n) l=150n m=(1)*(1)
    mp35 (net417 mout VDD VDD) pfet_01v8 w=(780n) l=150n m=(1)*(1)
    mp20 (CKb CK VDD VDD) pfet_01v8 w=(780n) l=150n m=(1)*(1)
    mp52 (n35 CKbb net405 VDD) pfet_01v8 w=(780n) l=150n m=(1)*(1)
    mp51 (net405 qbint VDD VDD) pfet_01v8 w=(780n) l=150n m=(1)*(1)
    mp50 (net405 SN VDD VDD) pfet_01v8 w=(780n) l=150n m=(1)*(1)
    mp45 (qbint n35 VDD VDD) pfet_01v8 w=1.13u l=150n m=1
    mp56 (net492 qbint VDD VDD) pfet_01v8 w=1.13u l=150n m=1
    mp21 (CKbb CKb VDD VDD) pfet_01v8 w=(780n) l=150n m=(1)*(1)
    mp40 (n35 CKb mout VDD) pfet_01v8 w=(780n) l=150n m=(1)*(1)
    mp30 (mout SN VDD VDD) pfet_01v8 w=(780n) l=150n m=(1)*(1)
    mp31 (mout n20 VDD VDD) pfet_01v8 w=(780n) l=150n m=(1)*(1)
    mp25 (n20 CKbb Db VDD) pfet_01v8 w=(780n) l=150n m=(1)*(1)
    mp10 (SEb SE VDD VDD) pfet_01v8 w=1.13u l=150n m=1
    mn51 (net518 qbint net521 VSS) nfet_01v8_lvt w=(425n) l=150n m=(1)*(1)
    mn52 (n35 CKb net518 VSS) nfet_01v8_lvt w=(425n) l=150n m=(1)*(1)
    mn50 (net521 SN VSS VSS) nfet_01v8_lvt w=(425n) l=150n m=(1)*(1)
    mn13 (net506 SI VSS VSS) nfet_01v8_lvt w=(425n) l=150n m=(1)*(1)
    mn14 (Db SE net506 VSS) nfet_01v8_lvt w=(425n) l=150n m=(1)*(1)
    mn12 (Db SEb net494 VSS) nfet_01v8_lvt w=(425n) l=150n m=(1)*(1)
    mn11 (net494 D VSS VSS) nfet_01v8_lvt w=(425n) l=150n m=(1)*(1)
    mn57 (QN net492 VSS VSS) nfet_01v8_lvt w=(760n) l=150n m=(1)*(4)
    mn55 (Q qbint VSS VSS) nfet_01v8_lvt w=(760n) l=150n m=(1)*(4)
    mn31 (mout n20 net442 VSS) nfet_01v8_lvt w=(425n) l=150n m=(1)*(1)
    mn35 (net478 mout VSS VSS) nfet_01v8_lvt w=(425n) l=150n m=(1)*(1)
    mn36 (n20 CKbb net478 VSS) nfet_01v8_lvt w=(425n) l=150n m=(1)*(1)
    mn20 (CKb CK VSS VSS) nfet_01v8_lvt w=(425n) l=150n m=(1)*(1)
    mn45 (qbint n35 VSS VSS) nfet_01v8_lvt w=(600n) l=150n m=(1)*(2)
    mn56 (net492 qbint VSS VSS) nfet_01v8_lvt w=(760n) l=150n m=(1)*(1)
    mn21 (CKbb CKb VSS VSS) nfet_01v8_lvt w=(425n) l=150n m=(1)*(1)
    mn40 (n35 CKbb mout VSS) nfet_01v8_lvt w=(425n) l=150n m=(1)*(1)
    mn10 (SEb SE VSS VSS) nfet_01v8_lvt w=(425n) l=150n m=(1)*(1)
    mn25 (Db CKb n20 VSS) nfet_01v8_lvt w=(425n) l=150n m=(1)*(1)
    mn30 (net442 SN VSS VSS) nfet_01v8_lvt w=(425n) l=150n m=(1)*(1)
ends SDFFSX4_HS

// sky130_scl_9T_HS/OR2X2_HS/schematic
subckt OR2X2_HS A B VDD VSS Y
    mp1 (n0 B n1 VDD) pfet_01v8 w=(780n) l=150n m=(1)*(1)
    mp2 (Y n0 VDD VDD) pfet_01v8 w=1.13u l=150n m=2
    mp0 (n1 A VDD VDD) pfet_01v8 w=1.13u l=150n m=2
    mn2 (Y n0 VSS VSS) nfet_01v8_lvt w=(760n) l=150n m=(1)*(2)
    mn0 (n0 A VSS VSS) nfet_01v8_lvt w=(425n) l=150n m=(1)*(1)
    mn1 (n0 B VSS VSS) nfet_01v8_lvt w=(425n) l=150n m=(1)*(1)
ends OR2X2_HS

// sky130_scl_9T_HS/DLY2X4_HS/schematic
subckt DLY2X4_HS A VDD VSS Y
    mp6 (n3 VSS n11 VDD) pfet_01v8 w=(780n) l=150n m=(1)*(1)
    mp5 (n11 n2 VDD VDD) pfet_01v8 w=(780n) l=150n m=(1)*(1)
    mp8 (Y n4 VDD VDD) pfet_01v8 w=(1.46u) l=150n m=(1)*(4)
    mp4 (n2 VSS n9 VDD) pfet_01v8 w=(780n) l=150n m=(1)*(1)
    mp3 (n9 n1 VDD VDD) pfet_01v8 w=(780n) l=150n m=(1)*(1)
    mp2 (n1 VSS n7 VDD) pfet_01v8 w=(780n) l=150n m=(1)*(1)
    mp1 (n7 n0 VDD VDD) pfet_01v8 w=(780n) l=150n m=(1)*(1)
    mp7 (n4 n3 VDD VDD) pfet_01v8 w=(1.46u) l=150n m=(1)*(1)
    mp0 (n0 A VDD VDD) pfet_01v8 w=(780n) l=150n m=(1)*(1)
    mn6 (n3 VDD n10 VSS) nfet_01v8_lvt w=(425n) l=150n m=(1)*(1)
    mn5 (n10 n2 VSS VSS) nfet_01v8_lvt w=(425n) l=150n m=(1)*(1)
    mn8 (Y n4 VSS VSS) nfet_01v8_lvt w=(760n) l=150n m=(1)*(4)
    mn4 (n2 VDD n8 VSS) nfet_01v8_lvt w=(425n) l=150n m=(1)*(1)
    mn3 (n8 n1 VSS VSS) nfet_01v8_lvt w=(425n) l=150n m=(1)*(1)
    mn2 (n1 VDD n6 VSS) nfet_01v8_lvt w=(425n) l=150n m=(1)*(1)
    mn1 (n6 n0 VSS VSS) nfet_01v8_lvt w=(425n) l=150n m=(1)*(1)
    mn7 (n4 n3 VSS VSS) nfet_01v8_lvt w=(760n) l=150n m=(1)*(1)
    mn0 (n0 A VSS VSS) nfet_01v8_lvt w=(425n) l=150n m=(1)*(1)
ends DLY2X4_HS

// sky130_scl_9T_HS/SDFFX1_HS/schematic
subckt SDFFX1_HS CK D Q QN SE SI VDD VSS
    mp14 (Db SEb net392 VDD) pfet_01v8 w=(780n) l=150n m=(1)*(1)
    mp13 (net392 SI VDD VDD) pfet_01v8 w=(780n) l=150n m=(1)*(1)
    mp12 (Db SE net384 VDD) pfet_01v8 w=(780n) l=150n m=(1)*(1)
    mp11 (net384 D VDD VDD) pfet_01v8 w=(780n) l=150n m=(1)*(1)
    mp51 (n30 CKbb net376 VDD) pfet_01v8 w=(780n) l=150n m=(1)*(1)
    mp50 (net376 qbint VDD VDD) pfet_01v8 w=(780n) l=150n m=(1)*(1)
    mp57 (QN net367 VDD VDD) pfet_01v8 w=(1.46u) l=150n m=(1)*(1)
    mp55 (Q qbint VDD VDD) pfet_01v8 w=1.13u l=150n m=1
    mp35 (net356 mout VDD VDD) pfet_01v8 w=(780n) l=150n m=(1)*(1)
    mp36 (n20 CKb net356 VDD) pfet_01v8 w=(780n) l=150n m=(1)*(1)
    mp20 (CKb CK VDD VDD) pfet_01v8 w=(780n) l=150n m=(1)*(1)
    mp45 (qbint n30 VDD VDD) pfet_01v8 w=(780n) l=150n m=(1)*(1)
    mp56 (net367 qbint VDD VDD) pfet_01v8 w=(780n) l=150n m=(1)*(1)
    mp21 (CKbb CKb VDD VDD) pfet_01v8 w=(780n) l=150n m=(1)*(1)
    mp40 (n30 CKb mout VDD) pfet_01v8 w=(780n) l=150n m=(1)*(1)
    mp30 (mout n20 VDD VDD) pfet_01v8 w=(780n) l=150n m=(1)*(1)
    mp25 (n20 CKbb Db VDD) pfet_01v8 w=(780n) l=150n m=(1)*(1)
    mp10 (SEb SE VDD VDD) pfet_01v8 w=1.13u l=150n m=1
    mn13 (net461 SI VSS VSS) nfet_01v8_lvt w=(425n) l=150n m=(1)*(1)
    mn14 (Db SE net461 VSS) nfet_01v8_lvt w=(425n) l=150n m=(1)*(1)
    mn12 (Db SEb net449 VSS) nfet_01v8_lvt w=(425n) l=150n m=(1)*(1)
    mn11 (net449 D VSS VSS) nfet_01v8_lvt w=(425n) l=150n m=(1)*(1)
    mn57 (QN net367 VSS VSS) nfet_01v8_lvt w=(760n) l=150n m=(1)*(1)
    mn55 (Q qbint VSS VSS) nfet_01v8_lvt w=(760n) l=150n m=(1)*(1)
    mn50 (net436 qbint VSS VSS) nfet_01v8_lvt w=(425n) l=150n m=(1)*(1)
    mn51 (n30 CKb net436 VSS) nfet_01v8_lvt w=(425n) l=150n m=(1)*(1)
    mn35 (net429 mout VSS VSS) nfet_01v8_lvt w=(425n) l=150n m=(1)*(1)
    mn36 (n20 CKbb net429 VSS) nfet_01v8_lvt w=(425n) l=150n m=(1)*(1)
    mn20 (CKb CK VSS VSS) nfet_01v8_lvt w=(425n) l=150n m=(1)*(1)
    mn45 (qbint n30 VSS VSS) nfet_01v8_lvt w=(425n) l=150n m=(1)*(1)
    mn56 (net367 qbint VSS VSS) nfet_01v8_lvt w=(425n) l=150n m=(1)*(1)
    mn21 (CKbb CKb VSS VSS) nfet_01v8_lvt w=(425n) l=150n m=(1)*(1)
    mn40 (n30 CKbb mout VSS) nfet_01v8_lvt w=(425n) l=150n m=(1)*(1)
    mn30 (mout n20 VSS VSS) nfet_01v8_lvt w=(425n) l=150n m=(1)*(1)
    mn10 (SEb SE VSS VSS) nfet_01v8_lvt w=(425n) l=150n m=(1)*(1)
    mn25 (n20 CKb Db VSS) nfet_01v8_lvt w=(425n) l=150n m=(1)*(1)
ends SDFFX1_HS

// sky130_scl_9T_HS/OR2X1_HS/schematic
subckt OR2X1_HS A B VDD VSS Y
    mp1 (n0 B n1 VDD) pfet_01v8 w=(780n) l=150n m=(1)*(1)
    mp2 (Y n0 VDD VDD) pfet_01v8 w=1.13u l=150n m=1
    mp0 (n1 A VDD VDD) pfet_01v8 w=1.13u l=150n m=1
    mn2 (Y n0 VSS VSS) nfet_01v8_lvt w=(760n) l=150n m=(1)*(1)
    mn0 (n0 A VSS VSS) nfet_01v8_lvt w=(425n) l=150n m=(1)*(1)
    mn1 (n0 B VSS VSS) nfet_01v8_lvt w=(425n) l=150n m=(1)*(1)
ends OR2X1_HS

// sky130_scl_9T_HS/OAI22X2_HS/schematic
subckt OAI22X2_HS A0 A1 B0 B1 VDD VSS Y
    mp3 (Y B1 net85 VDD) pfet_01v8 w=(1.46u) l=150n m=(1)*(2)
    mp1 (Y A1 net93 VDD) pfet_01v8 w=(1.46u) l=150n m=(1)*(2)
    mp0 (net93 A0 VDD VDD) pfet_01v8 w=1.13u l=150n m=2
    mp2 (net85 B0 VDD VDD) pfet_01v8 w=(1.46u) l=150n m=(1)*(2)
    mn0 (net102 A0 VSS VSS) nfet_01v8_lvt w=(760n) l=150n m=(1)*(2)
    mn3 (Y B1 net102 VSS) nfet_01v8_lvt w=(760n) l=150n m=(1)*(2)
    mn1 (net102 A1 VSS VSS) nfet_01v8_lvt w=(760n) l=150n m=(1)*(2)
    mn2 (Y B0 net102 VSS) nfet_01v8_lvt w=(760n) l=150n m=(1)*(2)
ends OAI22X2_HS

// sky130_scl_9T_HS/ADDFX1_HS/schematic
subckt ADDFX1_HS A B CI CO S VDD VSS
    mp9 (n8 A VDD VDD) pfet_01v8 w=(780n) l=150n m=(1)*(1)
    mp10 (n9 B n8 VDD) pfet_01v8 w=(780n) l=150n m=(1)*(1)
    mp11 (Sb CI n9 VDD) pfet_01v8 w=1.13u l=150n m=1
    mp13 (S Sb VDD VDD) pfet_01v8 w=(1.46u) l=150n m=(1)*(1)
    mp12 (CO COb VDD VDD) pfet_01v8 w=1.13u l=150n m=1
    mp1 (COb B n1 VDD) pfet_01v8 w=(780n) l=150n m=(1)*(1)
    mp0 (n1 A VDD VDD) pfet_01v8 w=(780n) l=150n m=(1)*(1)
    mp2 (n3 A VDD VDD) pfet_01v8 w=(780n) l=150n m=(1)*(1)
    mp4 (COb CI n3 VDD) pfet_01v8 w=(780n) l=150n m=(1)*(1)
    mp5 (n5 A VDD VDD) pfet_01v8 w=(780n) l=150n m=(1)*(1)
    mp6 (n5 B VDD VDD) pfet_01v8 w=(780n) l=150n m=(1)*(1)
    mp7 (n5 CI VDD VDD) pfet_01v8 w=(780n) l=150n m=(1)*(1)
    mp3 (n3 B VDD VDD) pfet_01v8 w=(780n) l=150n m=(1)*(1)
    mp8 (Sb COb n5 VDD) pfet_01v8 w=(780n) l=150n m=(1)*(1)
    mn9 (n6 A VSS VSS) nfet_01v8_lvt w=(425n) l=150n m=(1)*(1)
    mn10 (n7 B n6 VSS) nfet_01v8_lvt w=(425n) l=150n m=(1)*(1)
    mn11 (Sb CI n7 VSS) nfet_01v8_lvt w=(425n) l=150n m=(1)*(1)
    mn13 (S Sb VSS VSS) nfet_01v8_lvt w=(760n) l=150n m=(1)*(1)
    mn12 (CO COb VSS VSS) nfet_01v8_lvt w=(760n) l=150n m=(1)*(1)
    mn1 (COb B n0 VSS) nfet_01v8_lvt w=(425n) l=150n m=(1)*(1)
    mn2 (n2 A VSS VSS) nfet_01v8_lvt w=(425n) l=150n m=(1)*(1)
    mn0 (n0 A VSS VSS) nfet_01v8_lvt w=(425n) l=150n m=(1)*(1)
    mn7 (n4 CI VSS VSS) nfet_01v8_lvt w=(425n) l=150n m=(1)*(1)
    mn8 (Sb COb n4 VSS) nfet_01v8_lvt w=(425n) l=150n m=(1)*(1)
    mn3 (n2 B VSS VSS) nfet_01v8_lvt w=(425n) l=150n m=(1)*(1)
    mn6 (n4 B VSS VSS) nfet_01v8_lvt w=(425n) l=150n m=(1)*(1)
    mn5 (n4 A VSS VSS) nfet_01v8_lvt w=(425n) l=150n m=(1)*(1)
    mn4 (COb CI n2 VSS) nfet_01v8_lvt w=(425n) l=150n m=(1)*(1)
ends ADDFX1_HS

// sky130_scl_9T_HS/OAI211X2_HS/schematic
subckt OAI211X2_HS A0 A1 B0 C0 VDD VSS Y
    mp1 (Y A1 n2 VDD) pfet_01v8 w=(1.46u) l=150n m=(1)*(2)
    mp0 (n2 A0 VDD VDD) pfet_01v8 w=1.13u l=150n m=2
    mp3 (Y C0 VDD VDD) pfet_01v8 w=(1.46u) l=150n m=(1)*(2)
    mp2 (Y B0 VDD VDD) pfet_01v8 w=(1.46u) l=150n m=(1)*(2)
    mn1 (n0 A1 VSS VSS) nfet_01v8_lvt w=(760n) l=150n m=(1)*(2)
    mn0 (n0 A0 VSS VSS) nfet_01v8_lvt w=(760n) l=150n m=(1)*(2)
    mn2 (n1 B0 n0 VSS) nfet_01v8_lvt w=(760n) l=150n m=(1)*(2)
    mn3 (Y C0 n1 VSS) nfet_01v8_lvt w=(760n) l=150n m=(1)*(2)
ends OAI211X2_HS

// sky130_scl_9T_HS/AOI211X2_HS/schematic
subckt AOI211X2_HS A0 A1 B0 C0 VDD VSS Y
    mp3 (Y C0 net82 VDD) pfet_01v8 w=1.13u l=150n m=1
    mp2 (net82 B0 net91 VDD) pfet_01v8 w=(1.46u) l=150n m=(1)*(2)
    mp1 (net91 A1 VDD VDD) pfet_01v8 w=(1.46u) l=150n m=(1)*(2)
    mp0 (net91 A0 VDD VDD) pfet_01v8 w=(1.46u) l=150n m=(1)*(2)
    mn2 (Y B0 VSS VSS) nfet_01v8_lvt w=(760n) l=150n m=(1)*(2)
    mn3 (Y C0 VSS VSS) nfet_01v8_lvt w=(760n) l=150n m=(1)*(2)
    mn1 (Y A1 net95 VSS) nfet_01v8_lvt w=(760n) l=150n m=(1)*(2)
    mn0 (net95 A0 VSS VSS) nfet_01v8_lvt w=(760n) l=150n m=(1)*(2)
ends AOI211X2_HS

// sky130_scl_9T_HS/NAND3X1_HS/schematic
subckt NAND3X1_HS A B C VDD VSS Y
    mp0 (Y A VDD VDD) pfet_01v8 w=(1.46u) l=150n m=(1)*(1)
    mp1 (Y B VDD VDD) pfet_01v8 w=(1.46u) l=150n m=(1)*(1)
    mp2 (Y C VDD VDD) pfet_01v8 w=625n l=150n m=1
    mn1 (n0 B n1 VSS) nfet_01v8_lvt w=(760n) l=150n m=(1)*(1)
    mn2 (Y C n0 VSS) nfet_01v8_lvt w=(760n) l=150n m=(1)*(1)
    mn0 (n1 A VSS VSS) nfet_01v8_lvt w=(760n) l=150n m=(1)*(1)
ends NAND3X1_HS

// sky130_scl_9T_HS/NOR2X1_HS/schematic
subckt NOR2X1_HS A B VDD VSS Y
    mp1 (Y B net41 VDD) pfet_01v8 w=(1.46u) l=150n m=(1)*(1)
    mp0 (net41 A VDD VDD) pfet_01v8 w=1.13u l=150n m=1
    mn1 (Y B VSS VSS) nfet_01v8_lvt w=(760n) l=150n m=(1)*(1)
    mn0 (Y A VSS VSS) nfet_01v8_lvt w=(760n) l=150n m=(1)*(1)
ends NOR2X1_HS

// sky130_scl_9T_HS/SDFFSX1_HS/schematic
subckt SDFFSX1_HS CK D Q QN SE SI SN VDD VSS
    mp14 (Db SEb net441 VDD) pfet_01v8 w=(780n) l=150n m=(1)*(1)
    mp13 (net441 SI VDD VDD) pfet_01v8 w=(780n) l=150n m=(1)*(1)
    mp12 (Db SE net433 VDD) pfet_01v8 w=(780n) l=150n m=(1)*(1)
    mp11 (net433 D VDD VDD) pfet_01v8 w=(780n) l=150n m=(1)*(1)
    mp57 (QN net492 VDD VDD) pfet_01v8 w=(1.46u) l=150n m=(1)*(1)
    mp55 (Q qbint VDD VDD) pfet_01v8 w=1.13u l=150n m=1
    mp36 (n20 CKb net417 VDD) pfet_01v8 w=(780n) l=150n m=(1)*(1)
    mp35 (net417 mout VDD VDD) pfet_01v8 w=(780n) l=150n m=(1)*(1)
    mp20 (CKb CK VDD VDD) pfet_01v8 w=(780n) l=150n m=(1)*(1)
    mp52 (n35 CKbb net405 VDD) pfet_01v8 w=(780n) l=150n m=(1)*(1)
    mp51 (net405 qbint VDD VDD) pfet_01v8 w=(780n) l=150n m=(1)*(1)
    mp50 (net405 SN VDD VDD) pfet_01v8 w=(780n) l=150n m=(1)*(1)
    mp45 (qbint n35 VDD VDD) pfet_01v8 w=(780n) l=150n m=(1)*(1)
    mp56 (net492 qbint VDD VDD) pfet_01v8 w=(780n) l=150n m=(1)*(1)
    mp21 (CKbb CKb VDD VDD) pfet_01v8 w=(780n) l=150n m=(1)*(1)
    mp40 (n35 CKb mout VDD) pfet_01v8 w=(780n) l=150n m=(1)*(1)
    mp30 (mout SN VDD VDD) pfet_01v8 w=(780n) l=150n m=(1)*(1)
    mp31 (mout n20 VDD VDD) pfet_01v8 w=(780n) l=150n m=(1)*(1)
    mp25 (n20 CKbb Db VDD) pfet_01v8 w=(780n) l=150n m=(1)*(1)
    mp10 (SEb SE VDD VDD) pfet_01v8 w=1.13u l=150n m=1
    mn51 (net518 qbint net521 VSS) nfet_01v8_lvt w=(425n) l=150n m=(1)*(1)
    mn52 (n35 CKb net518 VSS) nfet_01v8_lvt w=(425n) l=150n m=(1)*(1)
    mn50 (net521 SN VSS VSS) nfet_01v8_lvt w=(425n) l=150n m=(1)*(1)
    mn13 (net506 SI VSS VSS) nfet_01v8_lvt w=(425n) l=150n m=(1)*(1)
    mn14 (Db SE net506 VSS) nfet_01v8_lvt w=(425n) l=150n m=(1)*(1)
    mn12 (Db SEb net494 VSS) nfet_01v8_lvt w=(425n) l=150n m=(1)*(1)
    mn11 (net494 D VSS VSS) nfet_01v8_lvt w=(425n) l=150n m=(1)*(1)
    mn57 (QN net492 VSS VSS) nfet_01v8_lvt w=(760n) l=150n m=(1)*(1)
    mn55 (Q qbint VSS VSS) nfet_01v8_lvt w=(760n) l=150n m=(1)*(1)
    mn31 (mout n20 net442 VSS) nfet_01v8_lvt w=(425n) l=150n m=(1)*(1)
    mn35 (net478 mout VSS VSS) nfet_01v8_lvt w=(425n) l=150n m=(1)*(1)
    mn36 (n20 CKbb net478 VSS) nfet_01v8_lvt w=(425n) l=150n m=(1)*(1)
    mn20 (CKb CK VSS VSS) nfet_01v8_lvt w=(425n) l=150n m=(1)*(1)
    mn45 (qbint n35 VSS VSS) nfet_01v8_lvt w=(425n) l=150n m=(1)*(1)
    mn56 (net492 qbint VSS VSS) nfet_01v8_lvt w=(425n) l=150n m=(1)*(1)
    mn21 (CKbb CKb VSS VSS) nfet_01v8_lvt w=(425n) l=150n m=(1)*(1)
    mn40 (n35 CKbb mout VSS) nfet_01v8_lvt w=(425n) l=150n m=(1)*(1)
    mn10 (SEb SE VSS VSS) nfet_01v8_lvt w=(425n) l=150n m=(1)*(1)
    mn25 (Db CKb n20 VSS) nfet_01v8_lvt w=(425n) l=150n m=(1)*(1)
    mn30 (net442 SN VSS VSS) nfet_01v8_lvt w=(425n) l=150n m=(1)*(1)
ends SDFFSX1_HS

// sky130_scl_9T_HS/BUFX16_HS/schematic
subckt BUFX16_HS A VDD VSS Y
    mp1 (Y n0 VDD VDD) pfet_01v8 w=1.13u l=150n m=2
    mp0 (n0 A VDD VDD) pfet_01v8 w=1.13u l=150n m=2
    mn1 (VSS n0 Y VSS) nfet_01v8_lvt w=(760n) l=150n m=(1)*(16)
    mn0 (VSS A n0 VSS) nfet_01v8_lvt w=(760n) l=150n m=(1)*(4)
ends BUFX16_HS

// sky130_scl_9T_HS/CLKMX2X2_HS/schematic
subckt CLKMX2X2_HS A B S0 VDD VSS Y
    mp4 (n0 S0b net115 VDD) pfet_01v8 w=(780n) l=150n m=(1)*(1)
    mp3 (net115 B VDD VDD) pfet_01v8 w=(780n) l=150n m=(1)*(1)
    mp5 (Y n0 VDD VDD) pfet_01v8 w=1.13u l=150n m=2
    mp2 (n0 S0 net123 VDD) pfet_01v8 w=1.13u l=150n m=2
    mp0 (S0b S0 VDD VDD) pfet_01v8 w=(780n) l=150n m=(1)*(1)
    mp1 (net123 A VDD VDD) pfet_01v8 w=(780n) l=150n m=(1)*(1)
    mn3 (net140 B VSS VSS) nfet_01v8_lvt w=(425n) l=150n m=(1)*(1)
    mn0 (S0b S0 VSS VSS) nfet_01v8_lvt w=(425n) l=150n m=(1)*(1)
    mn2 (n0 S0b net148 VSS) nfet_01v8_lvt w=(425n) l=150n m=(1)*(1)
    mn1 (net148 A VSS VSS) nfet_01v8_lvt w=(425n) l=150n m=(1)*(1)
    mn5 (Y n0 VSS VSS) nfet_01v8_lvt w=(760n) l=150n m=(1)*(2)
    mn4 (n0 S0 net140 VSS) nfet_01v8_lvt w=(425n) l=150n m=(1)*(1)
ends CLKMX2X2_HS

// sky130_scl_9T_HS/MX4X4_HS/schematic
subckt MX4X4_HS A B C D S0 S1 VDD VSS Y
    mp9 (n1 S0b n10 VDD) pfet_01v8 w=(780n) l=150n m=(1)*(1)
    mp8 (n10 D VDD VDD) pfet_01v8 w=(780n) l=150n m=(1)*(1)
    mp7 (n1 S0 n8 VDD) pfet_01v8 w=(780n) l=150n m=(1)*(1)
    mp6 (n8 C VDD VDD) pfet_01v8 w=(780n) l=150n m=(1)*(1)
    mp5 (n0 S0b n6 VDD) pfet_01v8 w=(780n) l=150n m=(1)*(1)
    mp4 (n6 B VDD VDD) pfet_01v8 w=(780n) l=150n m=(1)*(1)
    mp3 (n0 S0 n4 VDD) pfet_01v8 w=(780n) l=150n m=(1)*(1)
    mp2 (n4 A VDD VDD) pfet_01v8 w=(780n) l=150n m=(1)*(1)
    mp12 (Y n2 VDD VDD) pfet_01v8 w=1.13u l=150n m=1
    mp0 (S0b S0 VDD VDD) pfet_01v8 w=1.13u l=150n m=1
    mp10 (n2 S1 n0 VDD) pfet_01v8 w=1.13u l=150n m=1
    mp11 (n1 S1b n2 VDD) pfet_01v8 w=(1.46u) l=150n m=(1)*(1)
    mp1 (S1b S1 VDD VDD) pfet_01v8 w=(780n) l=150n m=(1)*(1)
    mn9 (n1 S0 n9 VSS) nfet_01v8_lvt w=(425n) l=150n m=(1)*(1)
    mn6 (n7 C VSS VSS) nfet_01v8_lvt w=(425n) l=150n m=(1)*(1)
    mn7 (n1 S0b n7 VSS) nfet_01v8_lvt w=(425n) l=150n m=(1)*(1)
    mn4 (n5 B VSS VSS) nfet_01v8_lvt w=(425n) l=150n m=(1)*(1)
    mn5 (n0 S0 n5 VSS) nfet_01v8_lvt w=(425n) l=150n m=(1)*(1)
    mn3 (n0 S0b n3 VSS) nfet_01v8_lvt w=(425n) l=150n m=(1)*(1)
    mn2 (n3 A VSS VSS) nfet_01v8_lvt w=(425n) l=150n m=(1)*(1)
    mn12 (Y n2 VSS VSS) nfet_01v8_lvt w=(760n) l=150n m=(1)*(4)
    mn1 (S1b S1 VSS VSS) nfet_01v8_lvt w=(425n) l=150n m=(1)*(1)
    mn11 (n2 S1 n1 VSS) nfet_01v8_lvt w=(760n) l=150n m=(1)*(1)
    mn8 (n9 D VSS VSS) nfet_01v8_lvt w=(425n) l=150n m=(1)*(1)
    mn10 (n2 S1b n0 VSS) nfet_01v8_lvt w=(760n) l=150n m=(1)*(1)
    mn0 (S0b S0 VSS VSS) nfet_01v8_lvt w=(425n) l=150n m=(1)*(1)
ends MX4X4_HS

// sky130_scl_9T_HS/TLATX1_HS/schematic
subckt TLATX1_HS D G Q QN VDD VSS
    mp26 (n0 Gb n22 VDD) pfet_01v8 w=(780n) l=150n m=(1)*(1)
    mp25 (n22 D VDD VDD) pfet_01v8 w=(780n) l=150n m=(1)*(1)
    mp57 (QN Qint VDD VDD) pfet_01v8 w=(1.46u) l=150n m=(1)*(1)
    mp55 (Qbint Qint VDD VDD) pfet_01v8 w=(1.46u) l=150n m=(1)*(1)
    mp35 (n26 Qint VDD VDD) pfet_01v8 w=(780n) l=150n m=(1)*(1)
    mp36 (n0 Gbb n26 VDD) pfet_01v8 w=625n l=150n m=1
    mp20 (Gb G VDD VDD) pfet_01v8 w=(780n) l=150n m=(1)*(1)
    mp56 (Q Qbint VDD VDD) pfet_01v8 w=625n l=150n m=1
    mp21 (Gbb Gb VDD VDD) pfet_01v8 w=(780n) l=150n m=(1)*(1)
    mp30 (Qint n0 VDD VDD) pfet_01v8 w=(780n) l=150n m=(1)*(1)
    mn26 (n0 Gbb n21 VSS) nfet_01v8_lvt w=(425n) l=150n m=(1)*(1)
    mn25 (n21 D VSS VSS) nfet_01v8_lvt w=(425n) l=150n m=(1)*(1)
    mn57 (QN Qint VSS VSS) nfet_01v8_lvt w=(760n) l=150n m=(1)*(1)
    mn55 (Qbint Qint VSS VSS) nfet_01v8_lvt w=(760n) l=150n m=(1)*(1)
    mn35 (n25 Qint VSS VSS) nfet_01v8_lvt w=(425n) l=150n m=(1)*(1)
    mn36 (n0 Gb n25 VSS) nfet_01v8_lvt w=(425n) l=150n m=(1)*(1)
    mn20 (Gb G VSS VSS) nfet_01v8_lvt w=(425n) l=150n m=(1)*(1)
    mn56 (Q Qbint VSS VSS) nfet_01v8_lvt w=(760n) l=150n m=(1)*(1)
    mn21 (Gbb Gb VSS VSS) nfet_01v8_lvt w=(425n) l=150n m=(1)*(1)
    mn30 (Qint n0 VSS VSS) nfet_01v8_lvt w=(425n) l=150n m=(1)*(1)
ends TLATX1_HS

// sky130_scl_9T_HS/TBUFX4_HS/schematic
subckt TBUFX4_HS A OE VDD VSS Y
    mp2 (non OEb net127 VDD) pfet_01v8 w=(1.46u) l=150n m=(1)*(1)
    mp1 (net127 A VDD VDD) pfet_01v8 w=(1.46u) l=150n m=(1)*(1)
    mp5 (Y pon VDD VDD) pfet_01v8 w=(1.46u) l=150n m=(1)*(4)
    mp3 (pon A VDD VDD) pfet_01v8 w=(1.46u) l=150n m=(1)*(1)
    mp4 (pon OE VDD VDD) pfet_01v8 w=(1.46u) l=150n m=(1)*(1)
    mp0 (OEb OE VDD VDD) pfet_01v8 w=(780n) l=150n m=(1)*(1)
    mn5 (Y non VSS VSS) nfet_01v8_lvt w=(760n) l=150n m=(1)*(4)
    mn3 (net144 A VSS VSS) nfet_01v8_lvt w=(760n) l=150n m=(1)*(1)
    mn0 (OEb OE VSS VSS) nfet_01v8_lvt w=(425n) l=150n m=(1)*(1)
    mn4 (pon OE net144 VSS) nfet_01v8_lvt w=(760n) l=150n m=(1)*(1)
    mn2 (non OEb VSS VSS) nfet_01v8_lvt w=(760n) l=150n m=(1)*(1)
    mn1 (non A VSS VSS) nfet_01v8_lvt w=(760n) l=150n m=(1)*(1)
ends TBUFX4_HS

// sky130_scl_9T_HS/CLKINVX1_HS/schematic
subckt CLKINVX1_HS A VDD VSS Y
    mp0 (Y A VDD VDD) pfet_01v8 w=(1.06u) l=150n m=(1)*(3)
    mn0 (Y A VSS VSS) nfet_01v8_lvt w=(760n) l=150n m=(1)*(1)
ends CLKINVX1_HS

// sky130_scl_9T_HS/NAND3X4_HS/schematic
subckt NAND3X4_HS A B C VDD VSS Y
    mp0 (Y A VDD VDD) pfet_01v8 w=(1.46u) l=150n m=(1)*(4)
    mp1 (Y B VDD VDD) pfet_01v8 w=(1.46u) l=150n m=(1)*(4)
    mp2 (Y C VDD VDD) pfet_01v8 w=1.13u l=150n m=2
    mn1 (n0 B n1 VSS) nfet_01v8_lvt w=(760n) l=150n m=(1)*(4)
    mn2 (Y C n0 VSS) nfet_01v8_lvt w=(760n) l=150n m=(1)*(4)
    mn0 (n1 A VSS VSS) nfet_01v8_lvt w=(760n) l=150n m=(1)*(4)
ends NAND3X4_HS

// sky130_scl_9T_HS/NOR2X4_HS/schematic
subckt NOR2X4_HS A B VDD VSS Y
    mp1 (Y B net41 VDD) pfet_01v8 w=(1.46u) l=150n m=(1)*(4)
    mp0 (net41 A VDD VDD) pfet_01v8 w=1.13u l=150n m=4
    mn1 (Y B VSS VSS) nfet_01v8_lvt w=(760n) l=150n m=(1)*(4)
    mn0 (Y A VSS VSS) nfet_01v8_lvt w=(760n) l=150n m=(1)*(4)
ends NOR2X4_HS

// sky130_scl_9T_HS/CLKINVX2_HS/schematic
subckt CLKINVX2_HS A VDD VSS Y
    mp0 (Y A VDD VDD) pfet_01v8 w=(1.06u) l=150n m=(1)*(6)
    mn0 (Y A VSS VSS) nfet_01v8_lvt w=(760n) l=150n m=(1)*(2)
ends CLKINVX2_HS

// sky130_scl_9T_HS/CLKAND2X2_HS/schematic
subckt CLKAND2X2_HS A B VDD VSS Y
    mp1 (net61 B VDD VDD) pfet_01v8 w=(780n) l=150n m=(1)*(1)
    mp0 (net61 A VDD VDD) pfet_01v8 w=(780n) l=150n m=(1)*(1)
    mp2 (Y net61 VDD VDD) pfet_01v8 w=(1.46u) l=150n m=(1)*(6)
    NM1 (net2 A VSS VSS) nfet_01v8_lvt w=(425n) l=150n m=(1)*(1)
    NM0 (net61 B net2 VSS) nfet_01v8_lvt w=(425n) l=150n m=(1)*(1)
    mn2 (Y net61 VSS VSS) nfet_01v8_lvt w=(760n) l=150n m=(1)*(2)
ends CLKAND2X2_HS

// sky130_scl_9T_HS/SDFFX4_HS/schematic
subckt SDFFX4_HS CK D Q QN SE SI VDD VSS
    mp14 (Db SEb net392 VDD) pfet_01v8 w=(780n) l=150n m=(1)*(1)
    mp13 (net392 SI VDD VDD) pfet_01v8 w=(780n) l=150n m=(1)*(1)
    mp12 (Db SE net384 VDD) pfet_01v8 w=(780n) l=150n m=(1)*(1)
    mp11 (net384 D VDD VDD) pfet_01v8 w=(780n) l=150n m=(1)*(1)
    mp51 (n30 CKbb net376 VDD) pfet_01v8 w=(780n) l=150n m=(1)*(1)
    mp50 (net376 qbint VDD VDD) pfet_01v8 w=(780n) l=150n m=(1)*(1)
    mp57 (QN net367 VDD VDD) pfet_01v8 w=(1.46u) l=150n m=(1)*(4)
    mp55 (Q qbint VDD VDD) pfet_01v8 w=1.13u l=150n m=1
    mp35 (net356 mout VDD VDD) pfet_01v8 w=(780n) l=150n m=(1)*(1)
    mp36 (n20 CKb net356 VDD) pfet_01v8 w=(780n) l=150n m=(1)*(1)
    mp20 (CKb CK VDD VDD) pfet_01v8 w=(780n) l=150n m=(1)*(1)
    mp45 (qbint n30 VDD VDD) pfet_01v8 w=1.13u l=150n m=1
    mp56 (net367 qbint VDD VDD) pfet_01v8 w=1.13u l=150n m=1
    mp21 (CKbb CKb VDD VDD) pfet_01v8 w=(780n) l=150n m=(1)*(1)
    mp40 (n30 CKb mout VDD) pfet_01v8 w=(780n) l=150n m=(1)*(1)
    mp30 (mout n20 VDD VDD) pfet_01v8 w=(780n) l=150n m=(1)*(1)
    mp25 (n20 CKbb Db VDD) pfet_01v8 w=(780n) l=150n m=(1)*(1)
    mp10 (SEb SE VDD VDD) pfet_01v8 w=1.13u l=150n m=1
    mn13 (net461 SI VSS VSS) nfet_01v8_lvt w=(425n) l=150n m=(1)*(1)
    mn14 (Db SE net461 VSS) nfet_01v8_lvt w=(425n) l=150n m=(1)*(1)
    mn12 (Db SEb net449 VSS) nfet_01v8_lvt w=(425n) l=150n m=(1)*(1)
    mn11 (net449 D VSS VSS) nfet_01v8_lvt w=(425n) l=150n m=(1)*(1)
    mn57 (QN net367 VSS VSS) nfet_01v8_lvt w=(760n) l=150n m=(1)*(4)
    mn55 (Q qbint VSS VSS) nfet_01v8_lvt w=(760n) l=150n m=(1)*(4)
    mn50 (net436 qbint VSS VSS) nfet_01v8_lvt w=(425n) l=150n m=(1)*(1)
    mn51 (n30 CKb net436 VSS) nfet_01v8_lvt w=(425n) l=150n m=(1)*(1)
    mn35 (net429 mout VSS VSS) nfet_01v8_lvt w=(425n) l=150n m=(1)*(1)
    mn36 (n20 CKbb net429 VSS) nfet_01v8_lvt w=(425n) l=150n m=(1)*(1)
    mn20 (CKb CK VSS VSS) nfet_01v8_lvt w=(425n) l=150n m=(1)*(1)
    mn45 (qbint n30 VSS VSS) nfet_01v8_lvt w=(600n) l=150n m=(1)*(2)
    mn56 (net367 qbint VSS VSS) nfet_01v8_lvt w=(760n) l=150n m=(1)*(1)
    mn21 (CKbb CKb VSS VSS) nfet_01v8_lvt w=(425n) l=150n m=(1)*(1)
    mn40 (n30 CKbb mout VSS) nfet_01v8_lvt w=(425n) l=150n m=(1)*(1)
    mn30 (mout n20 VSS VSS) nfet_01v8_lvt w=(425n) l=150n m=(1)*(1)
    mn10 (SEb SE VSS VSS) nfet_01v8_lvt w=(425n) l=150n m=(1)*(1)
    mn25 (n20 CKb Db VSS) nfet_01v8_lvt w=(425n) l=150n m=(1)*(1)
ends SDFFX4_HS

// sky130_scl_9T_HS/SDFFRX4_HS/schematic
subckt SDFFRX4_HS CK D Q QN RN SE SI VDD VSS
    mp14 (Db SEb n4 VDD) pfet_01v8 w=(780n) l=150n m=(1)*(1)
    mp13 (n4 SI VDD VDD) pfet_01v8 w=(780n) l=150n m=(1)*(1)
    mp12 (Db SE n2 VDD) pfet_01v8 w=(780n) l=150n m=(1)*(1)
    mp11 (n2 D VDD VDD) pfet_01v8 w=(780n) l=150n m=(1)*(1)
    mp51 (n30 Ckbb n8 VDD) pfet_01v8 w=(780n) l=150n m=(1)*(1)
    mp50 (n8 qbint VDD VDD) pfet_01v8 w=(780n) l=150n m=(1)*(1)
    mp55 (Q qbint VDD VDD) pfet_01v8 w=1.13u l=150n m=1
    mp20 (CKb CK VDD VDD) pfet_01v8 w=(780n) l=150n m=(1)*(1)
    mp46 (qbint n30 VDD VDD) pfet_01v8 w=(1.12u) l=150n m=(1)*(2)
    mp56 (qint qbint VDD VDD) pfet_01v8 w=1.13u l=150n m=1
    mp45 (qbint RN VDD VDD) pfet_01v8 w=1.13u l=150n m=1
    mp35 (n6 RN VDD VDD) pfet_01v8 w=(780n) l=150n m=(1)*(1)
    mp36 (n6 mout VDD VDD) pfet_01v8 w=(780n) l=150n m=(1)*(1)
    mp37 (n20 CKb n6 VDD) pfet_01v8 w=(780n) l=150n m=(1)*(1)
    mp40 (n30 CKb mout VDD) pfet_01v8 w=(780n) l=150n m=(1)*(1)
    mp30 (mout n20 VDD VDD) pfet_01v8 w=(780n) l=150n m=(1)*(1)
    mp21 (Ckbb CKb VDD VDD) pfet_01v8 w=(780n) l=150n m=(1)*(1)
    mp25 (n20 Ckbb Db VDD) pfet_01v8 w=(780n) l=150n m=(1)*(1)
    mp10 (SEb SE VDD VDD) pfet_01v8 w=1.13u l=150n m=1
    mp57 (QN qint VDD VDD) pfet_01v8 w=1.13u l=150n m=1
    mn36 (n5 mout n7 VSS) nfet_01v8_lvt w=(425n) l=150n m=(1)*(1)
    mn35 (n7 RN VSS VSS) nfet_01v8_lvt w=(425n) l=150n m=(1)*(1)
    mn37 (n20 Ckbb n5 VSS) nfet_01v8_lvt w=(425n) l=150n m=(1)*(1)
    mn13 (n3 SI VSS VSS) nfet_01v8_lvt w=(425n) l=150n m=(1)*(1)
    mn14 (Db SE n3 VSS) nfet_01v8_lvt w=(425n) l=150n m=(1)*(1)
    mn12 (Db SEb n1 VSS) nfet_01v8_lvt w=(425n) l=150n m=(1)*(1)
    mn11 (n1 D VSS VSS) nfet_01v8_lvt w=(425n) l=150n m=(1)*(1)
    mn57 (QN qint VSS VSS) nfet_01v8_lvt w=(760n) l=150n m=(1)*(4)
    mn55 (Q qbint VSS VSS) nfet_01v8_lvt w=(760n) l=150n m=(1)*(4)
    mn45 (n9 RN VSS VSS) nfet_01v8_lvt w=(600n) l=150n m=(1)*(2)
    mn46 (qbint n30 n9 VSS) nfet_01v8_lvt w=(600n) l=150n m=(1)*(2)
    mn51 (n30 CKb n11 VSS) nfet_01v8_lvt w=(425n) l=150n m=(1)*(1)
    mn50 (n11 qbint VSS VSS) nfet_01v8_lvt w=(425n) l=150n m=(1)*(1)
    mn20 (CKb CK VSS VSS) nfet_01v8_lvt w=(425n) l=150n m=(1)*(1)
    mn56 (qint qbint VSS VSS) nfet_01v8_lvt w=(760n) l=150n m=(1)*(1)
    mn40 (mout Ckbb n30 VSS) nfet_01v8_lvt w=(425n) l=150n m=(1)*(1)
    mn30 (mout n20 VSS VSS) nfet_01v8_lvt w=(425n) l=150n m=(1)*(1)
    mn21 (Ckbb CKb VSS VSS) nfet_01v8_lvt w=(425n) l=150n m=(1)*(1)
    mn10 (SEb SE VSS VSS) nfet_01v8_lvt w=(425n) l=150n m=(1)*(1)
    mn25 (Db CKb n20 VSS) nfet_01v8_lvt w=(425n) l=150n m=(1)*(1)
ends SDFFRX4_HS

// sky130_scl_9T_HS/OR3X2_HS/schematic
subckt OR3X2_HS A B C VDD VSS Y
    mp3 (Y n0 VDD VDD) pfet_01v8 w=1.13u l=150n m=2
    mp1 (n2 B n1 VDD) pfet_01v8 w=(780n) l=150n m=(1)*(1)
    mp2 (n0 C n2 VDD) pfet_01v8 w=(780n) l=150n m=(1)*(1)
    mp0 (n1 A VDD VDD) pfet_01v8 w=1.13u l=150n m=2
    mn3 (Y n0 VSS VSS) nfet_01v8_lvt w=(760n) l=150n m=(1)*(2)
    mn0 (n0 A VSS VSS) nfet_01v8_lvt w=(425n) l=150n m=(1)*(1)
    mn1 (n0 B VSS VSS) nfet_01v8_lvt w=(425n) l=150n m=(1)*(1)
    mn2 (n0 C VSS VSS) nfet_01v8_lvt w=(425n) l=150n m=(1)*(1)
ends OR3X2_HS

// sky130_scl_9T_HS/XOR2X4_HS/schematic
subckt XOR2X4_HS A B VDD VSS Y
    mp3 (n0 n2 net130 VDD) pfet_01v8 w=(1.46u) l=150n m=(1)*(1)
    mp1 (n2 B VDD VDD) pfet_01v8 w=(780n) l=150n m=(1)*(1)
    mp4 (n1 B n0 VDD) pfet_01v8 w=(1.46u) l=150n m=(1)*(1)
    mp0 (n1 A VDD VDD) pfet_01v8 w=1.13u l=150n m=1
    mp5 (Y n0 VDD VDD) pfet_01v8 w=1.13u l=150n m=1
    mp2 (net130 n1 VDD VDD) pfet_01v8 w=1.13u l=150n m=1
    mn1 (n2 B VSS VSS) nfet_01v8_lvt w=(425n) l=150n m=(1)*(1)
    mn0 (n1 A VSS VSS) nfet_01v8_lvt w=(425n) l=150n m=(1)*(1)
    mn5 (Y n0 VSS VSS) nfet_01v8_lvt w=(760n) l=150n m=(1)*(4)
    mn3 (n0 B net131 VSS) nfet_01v8_lvt w=(760n) l=150n m=(1)*(1)
    mn4 (n0 n2 n1 VSS) nfet_01v8_lvt w=(760n) l=150n m=(1)*(1)
    mn2 (net131 n1 VSS VSS) nfet_01v8_lvt w=(760n) l=150n m=(1)*(1)
ends XOR2X4_HS

// sky130_scl_9T_HS/OAI222X1_HS/schematic
subckt OAI222X1_HS A0 A1 B0 B1 C0 C1 VDD VSS Y
    mp5 (Y C1 n4 VDD) pfet_01v8 w=(1.46u) l=150n m=(1)*(1)
    mp4 (n4 C0 VDD VDD) pfet_01v8 w=(1.46u) l=150n m=(1)*(1)
    mp3 (Y B1 n3 VDD) pfet_01v8 w=(1.46u) l=150n m=(1)*(1)
    mp2 (n3 B0 VDD VDD) pfet_01v8 w=(1.46u) l=150n m=(1)*(1)
    mp1 (Y A1 n2 VDD) pfet_01v8 w=(1.46u) l=150n m=(1)*(1)
    mp0 (n2 A0 VDD VDD) pfet_01v8 w=1.13u l=150n m=2
    mn5 (Y C1 n0 VSS) nfet_01v8_lvt w=(760n) l=150n m=(1)*(1)
    mn4 (Y C0 n0 VSS) nfet_01v8_lvt w=(760n) l=150n m=(1)*(1)
    mn3 (n0 B1 n1 VSS) nfet_01v8_lvt w=(760n) l=150n m=(1)*(1)
    mn2 (n0 B0 n1 VSS) nfet_01v8_lvt w=(760n) l=150n m=(1)*(1)
    mn0 (n1 A0 VSS VSS) nfet_01v8_lvt w=(760n) l=150n m=(1)*(1)
    mn1 (n1 A1 VSS VSS) nfet_01v8_lvt w=(760n) l=150n m=(1)*(1)
ends OAI222X1_HS

// sky130_scl_9T_HS/NAND2X2_HS/schematic
subckt NAND2X2_HS A B VDD VSS Y
    mp1 (Y B VDD VDD) pfet_01v8 w=(1.46u) l=150n m=(1)*(2)
    mp0 (Y A VDD VDD) pfet_01v8 w=1.13u l=150n m=1
    mn1 (Y B n0 VSS) nfet_01v8_lvt w=(760n) l=150n m=(1)*(2)
    mn0 (n0 A VSS VSS) nfet_01v8_lvt w=(760n) l=150n m=(1)*(2)
ends NAND2X2_HS

// sky130_scl_9T_HS/NOR3X2_HS/schematic
subckt NOR3X2_HS A B C VDD VSS Y
    mp1 (n1 B n0 VDD) pfet_01v8 w=(1.46u) l=150n m=(1)*(2)
    mp2 (Y C n1 VDD) pfet_01v8 w=(1.46u) l=150n m=(1)*(2)
    mp0 (n0 A VDD VDD) pfet_01v8 w=1.13u l=150n m=2
    mn0 (Y A VSS VSS) nfet_01v8_lvt w=(760n) l=150n m=(1)*(2)
    mn1 (Y B VSS VSS) nfet_01v8_lvt w=(760n) l=150n m=(1)*(2)
    mn2 (Y C VSS VSS) nfet_01v8_lvt w=(760n) l=150n m=(1)*(2)
ends NOR3X2_HS

// sky130_scl_9T_HS/AOI222X1_HS/schematic
subckt AOI222X1_HS A0 A1 B0 B1 C0 C1 VDD VSS Y
    mp5 (Y C1 net118 VDD) pfet_01v8 w=(1.46u) l=150n m=(1)*(1)
    mp4 (Y C0 net118 VDD) pfet_01v8 w=1.13u l=150n m=2
    mp3 (net118 B1 net122 VDD) pfet_01v8 w=(1.46u) l=150n m=(1)*(1)
    mp2 (net118 B0 net122 VDD) pfet_01v8 w=(1.46u) l=150n m=(1)*(1)
    mp0 (net122 A0 VDD VDD) pfet_01v8 w=(1.46u) l=150n m=(1)*(1)
    mp1 (net122 A1 VDD VDD) pfet_01v8 w=(1.46u) l=150n m=(1)*(1)
    mn5 (Y C1 net155 VSS) nfet_01v8_lvt w=(760n) l=150n m=(1)*(1)
    mn4 (net155 C0 VSS VSS) nfet_01v8_lvt w=(760n) l=150n m=(1)*(1)
    mn2 (net147 B0 VSS VSS) nfet_01v8_lvt w=(760n) l=150n m=(1)*(1)
    mn0 (net139 A0 VSS VSS) nfet_01v8_lvt w=(760n) l=150n m=(1)*(1)
    mn1 (Y A1 net139 VSS) nfet_01v8_lvt w=(760n) l=150n m=(1)*(1)
    mn3 (Y B1 net147 VSS) nfet_01v8_lvt w=(760n) l=150n m=(1)*(1)
ends AOI222X1_HS

// sky130_scl_9T_HS/AOI22X1_HS/schematic
subckt AOI22X1_HS A0 A1 B0 B1 VDD VSS Y
    mp3 (Y B1 net89 VDD) pfet_01v8 w=(1.46u) l=150n m=(1)*(1)
    mp0 (net89 A0 VDD VDD) pfet_01v8 w=(1.46u) l=150n m=(1)*(1)
    mp1 (net89 A1 VDD VDD) pfet_01v8 w=(1.46u) l=150n m=(1)*(1)
    mp2 (Y B0 net89 VDD) pfet_01v8 w=1.13u l=150n m=2
    mn3 (Y B1 net98 VSS) nfet_01v8_lvt w=(760n) l=150n m=(1)*(1)
    mn0 (net102 A0 VSS VSS) nfet_01v8_lvt w=(760n) l=150n m=(1)*(1)
    mn2 (net98 B0 VSS VSS) nfet_01v8_lvt w=(760n) l=150n m=(1)*(1)
    mn1 (Y A1 net102 VSS) nfet_01v8_lvt w=(760n) l=150n m=(1)*(1)
ends AOI22X1_HS

// sky130_scl_9T_HS/AOI22X2_HS/schematic
subckt AOI22X2_HS A0 A1 B0 B1 VDD VSS Y
    mp3 (Y B1 net89 VDD) pfet_01v8 w=(1.46u) l=150n m=(1)*(2)
    mp0 (net89 A0 VDD VDD) pfet_01v8 w=(1.46u) l=150n m=(1)*(2)
    mp1 (net89 A1 VDD VDD) pfet_01v8 w=(1.46u) l=150n m=(1)*(2)
    mp2 (Y B0 net89 VDD) pfet_01v8 w=1.13u l=150n m=1
    mn3 (Y B1 net106 VSS) nfet_01v8_lvt w=(760n) l=150n m=(1)*(2)
    mn0 (net98 A0 VSS VSS) nfet_01v8_lvt w=(760n) l=150n m=(1)*(2)
    mn2 (net106 B0 VSS VSS) nfet_01v8_lvt w=(760n) l=150n m=(1)*(2)
    mn1 (Y A1 net98 VSS) nfet_01v8_lvt w=(760n) l=150n m=(1)*(2)
ends AOI22X2_HS

// sky130_scl_9T_HS/NAND2X1_HS/schematic
subckt NAND2X1_HS A B VDD VSS Y
    mp1 (Y B VDD VDD) pfet_01v8 w=(1.46u) l=150n m=(1)*(1)
    mp0 (Y A VDD VDD) pfet_01v8 w=625n l=150n m=1
    mn1 (Y B n0 VSS) nfet_01v8_lvt w=(760n) l=150n m=(1)*(1)
    mn0 (n0 A VSS VSS) nfet_01v8_lvt w=(760n) l=150n m=(1)*(1)
ends NAND2X1_HS

// sky130_scl_9T_HS/NOR3X1_HS/schematic
subckt NOR3X1_HS A B C VDD VSS Y
    mp1 (n1 B n0 VDD) pfet_01v8 w=(1.46u) l=150n m=(1)*(1)
    mp2 (Y C n1 VDD) pfet_01v8 w=(1.46u) l=150n m=(1)*(1)
    mp0 (n0 A VDD VDD) pfet_01v8 w=1.13u l=150n m=1
    mn0 (Y A VSS VSS) nfet_01v8_lvt w=(760n) l=150n m=(1)*(1)
    mn1 (Y B VSS VSS) nfet_01v8_lvt w=(760n) l=150n m=(1)*(1)
    mn2 (Y C VSS VSS) nfet_01v8_lvt w=(760n) l=150n m=(1)*(1)
ends NOR3X1_HS

// sky130_scl_9T_HS/AOI222X2_HS/schematic
subckt AOI222X2_HS A0 A1 B0 B1 C0 C1 VDD VSS Y
    mp5 (Y C1 net134 VDD) pfet_01v8 w=(1.46u) l=150n m=(1)*(2)
    mp4 (Y C0 net134 VDD) pfet_01v8 w=1.13u l=150n m=1
    mp3 (net134 B1 net126 VDD) pfet_01v8 w=(1.46u) l=150n m=(1)*(2)
    mp2 (net134 B0 net126 VDD) pfet_01v8 w=(1.46u) l=150n m=(1)*(2)
    mp0 (net126 A0 VDD VDD) pfet_01v8 w=(1.46u) l=150n m=(1)*(2)
    mp1 (net126 A1 VDD VDD) pfet_01v8 w=(1.46u) l=150n m=(1)*(2)
    mn5 (Y C1 net155 VSS) nfet_01v8_lvt w=(760n) l=150n m=(1)*(2)
    mn4 (net155 C0 VSS VSS) nfet_01v8_lvt w=(760n) l=150n m=(1)*(2)
    mn2 (net151 B0 VSS VSS) nfet_01v8_lvt w=(760n) l=150n m=(1)*(2)
    mn0 (net147 A0 VSS VSS) nfet_01v8_lvt w=(760n) l=150n m=(1)*(2)
    mn1 (Y A1 net147 VSS) nfet_01v8_lvt w=(760n) l=150n m=(1)*(2)
    mn3 (Y B1 net151 VSS) nfet_01v8_lvt w=(760n) l=150n m=(1)*(2)
ends AOI222X2_HS

// sky130_scl_9T_HS/OR3X1_HS/schematic
subckt OR3X1_HS A B C VDD VSS Y
    mp3 (Y n0 VDD VDD) pfet_01v8 w=1.13u l=150n m=1
    mp1 (n2 B n1 VDD) pfet_01v8 w=(780n) l=150n m=(1)*(1)
    mp2 (n0 C n2 VDD) pfet_01v8 w=(780n) l=150n m=(1)*(1)
    mp0 (n1 A VDD VDD) pfet_01v8 w=1.13u l=150n m=1
    mn3 (Y n0 VSS VSS) nfet_01v8_lvt w=(760n) l=150n m=(1)*(1)
    mn0 (n0 A VSS VSS) nfet_01v8_lvt w=(425n) l=150n m=(1)*(1)
    mn1 (n0 B VSS VSS) nfet_01v8_lvt w=(425n) l=150n m=(1)*(1)
    mn2 (n0 C VSS VSS) nfet_01v8_lvt w=(425n) l=150n m=(1)*(1)
ends OR3X1_HS

// sky130_scl_9T_HS/CLKBUFX4_HS/schematic
subckt CLKBUFX4_HS A VDD VSS Y
    mp1 (Y net44 VDD VDD) pfet_01v8 w=(1.06u) l=150n m=(1)*(8)
    mp0 (net44 A VDD VDD) pfet_01v8 w=(1.46u) l=150n m=(1)*(1)
    mn1 (Y net44 VSS VSS) nfet_01v8_lvt w=(760n) l=150n m=(1)*(4)
    mn0 (net44 A VSS VSS) nfet_01v8_lvt w=(760n) l=150n m=(1)*(1)
ends CLKBUFX4_HS

// sky130_scl_9T_HS/OAI222X2_HS/schematic
subckt OAI222X2_HS A0 A1 B0 B1 C0 C1 VDD VSS Y
    mp5 (Y C1 n4 VDD) pfet_01v8 w=(1.46u) l=150n m=(1)*(2)
    mp4 (n4 C0 VDD VDD) pfet_01v8 w=(1.46u) l=150n m=(1)*(2)
    mp3 (Y B1 n3 VDD) pfet_01v8 w=(1.46u) l=150n m=(1)*(2)
    mp2 (n3 B0 VDD VDD) pfet_01v8 w=(1.46u) l=150n m=(1)*(2)
    mp1 (Y A1 n2 VDD) pfet_01v8 w=(1.46u) l=150n m=(1)*(2)
    mp0 (n2 A0 VDD VDD) pfet_01v8 w=1.13u l=150n m=2
    mn5 (Y C1 n0 VSS) nfet_01v8_lvt w=(760n) l=150n m=(1)*(2)
    mn4 (Y C0 n0 VSS) nfet_01v8_lvt w=(760n) l=150n m=(1)*(2)
    mn3 (n0 B1 n1 VSS) nfet_01v8_lvt w=(760n) l=150n m=(1)*(2)
    mn2 (n0 B0 n1 VSS) nfet_01v8_lvt w=(760n) l=150n m=(1)*(2)
    mn0 (n1 A0 VSS VSS) nfet_01v8_lvt w=(760n) l=150n m=(1)*(2)
    mn1 (n1 A1 VSS VSS) nfet_01v8_lvt w=(760n) l=150n m=(1)*(2)
ends OAI222X2_HS

// sky130_scl_9T_HS/CLKINVX8_HS/schematic
subckt CLKINVX8_HS A VDD VSS Y
    mp0 (Y A VDD VDD) pfet_01v8 w=(1.06u) l=150n m=(1)*(24)
    mn0 (Y A VSS VSS) nfet_01v8_lvt w=(760n) l=150n m=(1)*(8)
ends CLKINVX8_HS

// sky130_scl_9T_HS/AND4X1_HS/schematic
subckt AND4X1_HS A B C D VDD VSS Y
    mp3 (net116 D VDD VDD) pfet_01v8 w=(780n) l=150n m=(1)*(1)
    mp2 (net116 C VDD VDD) pfet_01v8 w=(780n) l=150n m=(1)*(1)
    mp1 (net116 B VDD VDD) pfet_01v8 w=(780n) l=150n m=(1)*(1)
    mp4 (Y net116 VDD VDD) pfet_01v8 w=625n l=150n m=1
    mp0 (net116 A VDD VDD) pfet_01v8 w=625n l=150n m=1
    mn3 (net116 D net132 VSS) nfet_01v8_lvt w=(425n) l=150n m=(1)*(1)
    mn2 (net132 C net128 VSS) nfet_01v8_lvt w=(425n) l=150n m=(1)*(1)
    mn4 (Y net116 VSS VSS) nfet_01v8_lvt w=(760n) l=150n m=(1)*(1)
    mn1 (net128 B net124 VSS) nfet_01v8_lvt w=(425n) l=150n m=(1)*(1)
    mn0 (net124 A VSS VSS) nfet_01v8_lvt w=(425n) l=150n m=(1)*(1)
ends AND4X1_HS

// sky130_scl_9T_HS/XOR2X1_HS/schematic
subckt XOR2X1_HS A B VDD VSS Y
    mp3 (n0 n2 net130 VDD) pfet_01v8 w=(780n) l=150n m=(1)*(1)
    mp1 (n2 B VDD VDD) pfet_01v8 w=(780n) l=150n m=(1)*(1)
    mp4 (n1 B n0 VDD) pfet_01v8 w=(780n) l=150n m=(1)*(1)
    mp0 (n1 A VDD VDD) pfet_01v8 w=625n l=150n m=1
    mp5 (Y n0 VDD VDD) pfet_01v8 w=625n l=150n m=1
    mp2 (net130 n1 VDD VDD) pfet_01v8 w=(780n) l=150n m=(1)*(1)
    mn1 (n2 B VSS VSS) nfet_01v8_lvt w=(425n) l=150n m=(1)*(1)
    mn0 (n1 A VSS VSS) nfet_01v8_lvt w=(425n) l=150n m=(1)*(1)
    mn5 (Y n0 VSS VSS) nfet_01v8_lvt w=(760n) l=150n m=(1)*(1)
    mn3 (n0 B net131 VSS) nfet_01v8_lvt w=(425n) l=150n m=(1)*(1)
    mn4 (n0 n2 n1 VSS) nfet_01v8_lvt w=(425n) l=150n m=(1)*(1)
    mn2 (net131 n1 VSS VSS) nfet_01v8_lvt w=(425n) l=150n m=(1)*(1)
ends XOR2X1_HS

// sky130_scl_9T_HS/SDFFRX1_HS/schematic
subckt SDFFRX1_HS CK D Q QN RN SE SI VDD VSS
    mp14 (Db SEb n4 VDD) pfet_01v8 w=(780n) l=150n m=(1)*(1)
    mp13 (n4 SI VDD VDD) pfet_01v8 w=(780n) l=150n m=(1)*(1)
    mp12 (Db SE n2 VDD) pfet_01v8 w=(780n) l=150n m=(1)*(1)
    mp11 (n2 D VDD VDD) pfet_01v8 w=(780n) l=150n m=(1)*(1)
    mp51 (n30 Ckbb n8 VDD) pfet_01v8 w=(780n) l=150n m=(1)*(1)
    mp50 (n8 qbint VDD VDD) pfet_01v8 w=(780n) l=150n m=(1)*(1)
    mp55 (Q qbint VDD VDD) pfet_01v8 w=625n l=150n m=1
    mp20 (CKb CK VDD VDD) pfet_01v8 w=(780n) l=150n m=(1)*(1)
    mp46 (qbint n30 VDD VDD) pfet_01v8 w=(780n) l=150n m=(1)*(1)
    mp56 (qint qbint VDD VDD) pfet_01v8 w=(780n) l=150n m=(1)*(1)
    mp45 (qbint RN VDD VDD) pfet_01v8 w=(780n) l=150n m=(1)*(1)
    mp35 (n6 RN VDD VDD) pfet_01v8 w=(780n) l=150n m=(1)*(1)
    mp36 (n6 mout VDD VDD) pfet_01v8 w=(780n) l=150n m=(1)*(1)
    mp37 (n20 CKb n6 VDD) pfet_01v8 w=625n l=150n m=1
    mp40 (n30 CKb mout VDD) pfet_01v8 w=(780n) l=150n m=(1)*(1)
    mp30 (mout n20 VDD VDD) pfet_01v8 w=(780n) l=150n m=(1)*(1)
    mp21 (Ckbb CKb VDD VDD) pfet_01v8 w=(780n) l=150n m=(1)*(1)
    mp25 (n20 Ckbb Db VDD) pfet_01v8 w=(780n) l=150n m=(1)*(1)
    mp10 (SEb SE VDD VDD) pfet_01v8 w=625n l=150n m=1
    mp57 (QN qint VDD VDD) pfet_01v8 w=(1.46u) l=150n m=(1)*(1)
    mn36 (n5 mout n7 VSS) nfet_01v8_lvt w=(425n) l=150n m=(1)*(1)
    mn35 (n7 RN VSS VSS) nfet_01v8_lvt w=(425n) l=150n m=(1)*(1)
    mn37 (n20 Ckbb n5 VSS) nfet_01v8_lvt w=(425n) l=150n m=(1)*(1)
    mn13 (n3 SI VSS VSS) nfet_01v8_lvt w=(425n) l=150n m=(1)*(1)
    mn14 (Db SE n3 VSS) nfet_01v8_lvt w=(425n) l=150n m=(1)*(1)
    mn12 (Db SEb n1 VSS) nfet_01v8_lvt w=(425n) l=150n m=(1)*(1)
    mn11 (n1 D VSS VSS) nfet_01v8_lvt w=(425n) l=150n m=(1)*(1)
    mn57 (QN qint VSS VSS) nfet_01v8_lvt w=(760n) l=150n m=(1)*(1)
    mn55 (Q qbint VSS VSS) nfet_01v8_lvt w=(760n) l=150n m=(1)*(1)
    mn45 (n9 RN VSS VSS) nfet_01v8_lvt w=(425n) l=150n m=(1)*(1)
    mn46 (qbint n30 n9 VSS) nfet_01v8_lvt w=(425n) l=150n m=(1)*(1)
    mn51 (n30 CKb n11 VSS) nfet_01v8_lvt w=(425n) l=150n m=(1)*(1)
    mn50 (n11 qbint VSS VSS) nfet_01v8_lvt w=(425n) l=150n m=(1)*(1)
    mn20 (CKb CK VSS VSS) nfet_01v8_lvt w=(425n) l=150n m=(1)*(1)
    mn56 (qint qbint VSS VSS) nfet_01v8_lvt w=(425n) l=150n m=(1)*(1)
    mn40 (mout Ckbb n30 VSS) nfet_01v8_lvt w=(425n) l=150n m=(1)*(1)
    mn30 (mout n20 VSS VSS) nfet_01v8_lvt w=(425n) l=150n m=(1)*(1)
    mn21 (Ckbb CKb VSS VSS) nfet_01v8_lvt w=(425n) l=150n m=(1)*(1)
    mn10 (SEb SE VSS VSS) nfet_01v8_lvt w=(425n) l=150n m=(1)*(1)
    mn25 (Db CKb n20 VSS) nfet_01v8_lvt w=(425n) l=150n m=(1)*(1)
ends SDFFRX1_HS

// sky130_scl_9T_HS/CLKBUFX2_HS/schematic
subckt CLKBUFX2_HS A VDD VSS Y
    mp1 (Y net44 VDD VDD) pfet_01v8 w=(1.06u) l=150n m=(1)*(4)
    mp0 (net44 A VDD VDD) pfet_01v8 w=(1.06u) l=150n m=(1)*(1)
    mn1 (Y net44 VSS VSS) nfet_01v8_lvt w=(760n) l=150n m=(1)*(2)
    mn0 (net44 A VSS VSS) nfet_01v8_lvt w=(760n) l=150n m=(1)*(1)
ends CLKBUFX2_HS

// sky130_scl_9T_HS/XOR2X2_HS/schematic
subckt XOR2X2_HS A B VDD VSS Y
    mp3 (n0 n2 net130 VDD) pfet_01v8 w=(780n) l=150n m=(1)*(1)
    mp1 (n2 B VDD VDD) pfet_01v8 w=(780n) l=150n m=(1)*(1)
    mp4 (n1 B n0 VDD) pfet_01v8 w=(780n) l=150n m=(1)*(1)
    mp0 (n1 A VDD VDD) pfet_01v8 w=1.13u l=150n m=2
    mp5 (Y n0 VDD VDD) pfet_01v8 w=1.13u l=150n m=2
    mp2 (net130 n1 VDD VDD) pfet_01v8 w=(780n) l=150n m=(1)*(1)
    mn1 (n2 B VSS VSS) nfet_01v8_lvt w=(425n) l=150n m=(1)*(1)
    mn0 (n1 A VSS VSS) nfet_01v8_lvt w=(425n) l=150n m=(1)*(1)
    mn5 (Y n0 VSS VSS) nfet_01v8_lvt w=(760n) l=150n m=(1)*(2)
    mn3 (n0 B net131 VSS) nfet_01v8_lvt w=(425n) l=150n m=(1)*(1)
    mn4 (n0 n2 n1 VSS) nfet_01v8_lvt w=(425n) l=150n m=(1)*(1)
    mn2 (net131 n1 VSS VSS) nfet_01v8_lvt w=(425n) l=150n m=(1)*(1)
ends XOR2X2_HS

// sky130_scl_9T_HS/TBUFX8_HS/schematic
subckt TBUFX8_HS A OE VDD VSS Y
    mp2 (non OEb net127 VDD) pfet_01v8 w=(1.46u) l=150n m=(1)*(2)
    mp1 (net127 A VDD VDD) pfet_01v8 w=625n l=150n m=1
    mp5 (Y pon VDD VDD) pfet_01v8 w=625n l=150n m=1
    mp3 (pon A VDD VDD) pfet_01v8 w=(1.46u) l=150n m=(1)*(2)
    mp4 (pon OE VDD VDD) pfet_01v8 w=(1.46u) l=150n m=(1)*(2)
    mp0 (OEb OE VDD VDD) pfet_01v8 w=625n l=150n m=1
    mn5 (Y non VSS VSS) nfet_01v8_lvt w=(760n) l=150n m=(1)*(8)
    mn3 (net144 A VSS VSS) nfet_01v8_lvt w=(760n) l=150n m=(1)*(2)
    mn0 (OEb OE VSS VSS) nfet_01v8_lvt w=(425n) l=150n m=(1)*(1)
    mn4 (pon OE net144 VSS) nfet_01v8_lvt w=(760n) l=150n m=(1)*(2)
    mn2 (non OEb VSS VSS) nfet_01v8_lvt w=(760n) l=150n m=(1)*(2)
    mn1 (non A VSS VSS) nfet_01v8_lvt w=(760n) l=150n m=(1)*(2)
ends TBUFX8_HS

// sky130_scl_9T_HS/AND4X2_HS/schematic
subckt AND4X2_HS A B C D VDD VSS Y
    mp3 (net100 D VDD VDD) pfet_01v8 w=(780n) l=150n m=(1)*(1)
    mp2 (net100 C VDD VDD) pfet_01v8 w=(780n) l=150n m=(1)*(1)
    mp1 (net100 B VDD VDD) pfet_01v8 w=(780n) l=150n m=(1)*(1)
    mp4 (Y net100 VDD VDD) pfet_01v8 w=625n l=150n m=1
    mp0 (net100 A VDD VDD) pfet_01v8 w=625n l=150n m=1
    mn3 (net100 D net132 VSS) nfet_01v8_lvt w=(425n) l=150n m=(1)*(1)
    mn2 (net132 C net124 VSS) nfet_01v8_lvt w=(425n) l=150n m=(1)*(1)
    mn4 (Y net100 VSS VSS) nfet_01v8_lvt w=(760n) l=150n m=(1)*(2)
    mn1 (net124 B net120 VSS) nfet_01v8_lvt w=(425n) l=150n m=(1)*(1)
    mn0 (net120 A VSS VSS) nfet_01v8_lvt w=(425n) l=150n m=(1)*(1)
ends AND4X2_HS

// sky130_scl_9T_HS/NOR3X4_HS/schematic
subckt NOR3X4_HS A B C VDD VSS Y
    mp1 (n1 B n0 VDD) pfet_01v8 w=(1.46u) l=150n m=(1)*(4)
    mp2 (Y C n1 VDD) pfet_01v8 w=(1.46u) l=150n m=(1)*(4)
    mp0 (n0 A VDD VDD) pfet_01v8 w=1.13u l=150n m=4
    mn0 (Y A VSS VSS) nfet_01v8_lvt w=(760n) l=150n m=(1)*(4)
    mn1 (Y B VSS VSS) nfet_01v8_lvt w=(760n) l=150n m=(1)*(4)
    mn2 (Y C VSS VSS) nfet_01v8_lvt w=(760n) l=150n m=(1)*(4)
ends NOR3X4_HS

// sky130_scl_9T_HS/NAND2X4_HS/schematic
subckt NAND2X4_HS A B VDD VSS Y
    mp1 (Y B VDD VDD) pfet_01v8 w=(1.46u) l=150n m=(1)*(4)
    mp0 (Y A VDD VDD) pfet_01v8 w=1.13u l=150n m=4
    mn1 (Y B n0 VSS) nfet_01v8_lvt w=(760n) l=150n m=(1)*(4)
    mn0 (n0 A VSS VSS) nfet_01v8_lvt w=(760n) l=150n m=(1)*(4)
ends NAND2X4_HS
